* NGSPICE file created from switch-cell.ext - technology: gf180mcuD

.subckt nfet_06v0_42FNXL a_436_n400# a_192_n400# a_n436_n444# a_n768_n400# a_n192_n444#
+ a_540_n444# a_n296_n400# a_n52_n400# a_680_n400# a_n680_n444# a_n540_n400# a_296_n444#
+ a_52_n444# VSUBS
X0 a_436_n400# a_296_n444# a_192_n400# VSUBS nfet_06v0 ad=1.04p pd=4.52u as=1.04p ps=4.52u w=4u l=0.7u
X1 a_680_n400# a_540_n444# a_436_n400# VSUBS nfet_06v0 ad=1.76p pd=8.88u as=1.04p ps=4.52u w=4u l=0.7u
X2 a_192_n400# a_52_n444# a_n52_n400# VSUBS nfet_06v0 ad=1.04p pd=4.52u as=1.04p ps=4.52u w=4u l=0.7u
X3 a_n52_n400# a_n192_n444# a_n296_n400# VSUBS nfet_06v0 ad=1.04p pd=4.52u as=1.04p ps=4.52u w=4u l=0.7u
X4 a_n296_n400# a_n436_n444# a_n540_n400# VSUBS nfet_06v0 ad=1.04p pd=4.52u as=1.04p ps=4.52u w=4u l=0.7u
X5 a_n540_n400# a_n680_n444# a_n768_n400# VSUBS nfet_06v0 ad=1.04p pd=4.52u as=1.76p ps=8.88u w=4u l=0.7u
.ends

.subckt pfet_06v0_LJSS4L a_376_n400# a_1764_n444# a_n590_n444# a_1122_n444# a_n376_n444#
+ a_908_n444# w_n2048_n530# a_n694_n400# a_480_n444# a_266_n444# a_n1660_n444# a_n1446_n444#
+ a_1660_n400# a_n52_n400# a_n1764_n400# a_1446_n400# a_804_n400# a_n1122_n400# a_1550_n444#
+ a_162_n400# a_1336_n444# a_n804_n444# a_694_n444# a_n162_n444# a_n480_n400# a_n908_n400#
+ a_n1874_n444# a_n266_n400# a_1874_n400# a_n1962_n400# a_52_n444# a_n1232_n444# a_1232_n400#
+ a_n1550_n400# a_n1018_n444# a_n1336_n400# a_1018_n400# a_590_n400#
X0 a_376_n400# a_266_n444# a_162_n400# w_n2048_n530# pfet_06v0 ad=1.04p pd=4.52u as=1.04p ps=4.52u w=4u l=0.55u
X1 a_1232_n400# a_1122_n444# a_1018_n400# w_n2048_n530# pfet_06v0 ad=1.04p pd=4.52u as=1.04p ps=4.52u w=4u l=0.55u
X2 a_n694_n400# a_n804_n444# a_n908_n400# w_n2048_n530# pfet_06v0 ad=1.04p pd=4.52u as=1.04p ps=4.52u w=4u l=0.55u
X3 a_n1550_n400# a_n1660_n444# a_n1764_n400# w_n2048_n530# pfet_06v0 ad=1.04p pd=4.52u as=1.04p ps=4.52u w=4u l=0.55u
X4 a_1446_n400# a_1336_n444# a_1232_n400# w_n2048_n530# pfet_06v0 ad=1.04p pd=4.52u as=1.04p ps=4.52u w=4u l=0.55u
X5 a_n908_n400# a_n1018_n444# a_n1122_n400# w_n2048_n530# pfet_06v0 ad=1.04p pd=4.52u as=1.04p ps=4.52u w=4u l=0.55u
X6 a_n52_n400# a_n162_n444# a_n266_n400# w_n2048_n530# pfet_06v0 ad=1.04p pd=4.52u as=1.04p ps=4.52u w=4u l=0.55u
X7 a_162_n400# a_52_n444# a_n52_n400# w_n2048_n530# pfet_06v0 ad=1.04p pd=4.52u as=1.04p ps=4.52u w=4u l=0.55u
X8 a_590_n400# a_480_n444# a_376_n400# w_n2048_n530# pfet_06v0 ad=1.04p pd=4.52u as=1.04p ps=4.52u w=4u l=0.55u
X9 a_n1764_n400# a_n1874_n444# a_n1962_n400# w_n2048_n530# pfet_06v0 ad=1.04p pd=4.52u as=1.76p ps=8.88u w=4u l=0.55u
X10 a_1018_n400# a_908_n444# a_804_n400# w_n2048_n530# pfet_06v0 ad=1.04p pd=4.52u as=1.04p ps=4.52u w=4u l=0.55u
X11 a_n266_n400# a_n376_n444# a_n480_n400# w_n2048_n530# pfet_06v0 ad=1.04p pd=4.52u as=1.04p ps=4.52u w=4u l=0.55u
X12 a_804_n400# a_694_n444# a_590_n400# w_n2048_n530# pfet_06v0 ad=1.04p pd=4.52u as=1.04p ps=4.52u w=4u l=0.55u
X13 a_1660_n400# a_1550_n444# a_1446_n400# w_n2048_n530# pfet_06v0 ad=1.04p pd=4.52u as=1.04p ps=4.52u w=4u l=0.55u
X14 a_n1122_n400# a_n1232_n444# a_n1336_n400# w_n2048_n530# pfet_06v0 ad=1.04p pd=4.52u as=1.04p ps=4.52u w=4u l=0.55u
X15 a_n480_n400# a_n590_n444# a_n694_n400# w_n2048_n530# pfet_06v0 ad=1.04p pd=4.52u as=1.04p ps=4.52u w=4u l=0.55u
X16 a_1874_n400# a_1764_n444# a_1660_n400# w_n2048_n530# pfet_06v0 ad=1.76p pd=8.88u as=1.04p ps=4.52u w=4u l=0.55u
X17 a_n1336_n400# a_n1446_n444# a_n1550_n400# w_n2048_n530# pfet_06v0 ad=1.04p pd=4.52u as=1.04p ps=4.52u w=4u l=0.55u
.ends

.subckt trans-gate SWP IN OUT VDD VSS SWN
Xnfet_06v0_42FNXL_0 IN OUT SWN OUT SWN SWN OUT IN OUT SWN IN SWN SWN VSS nfet_06v0_42FNXL
Xpfet_06v0_LJSS4L_0 OUT SWP SWP SWP SWP SWP VDD IN SWP SWP SWP SWP OUT OUT OUT IN
+ OUT IN SWP IN SWP SWP SWP SWP OUT OUT SWP IN IN IN SWP SWP OUT IN SWP OUT IN IN
+ pfet_06v0_LJSS4L
.ends

.subckt gf180mcu_fd_sc_mcu9t5v0__latq_1 D E Q VDD VNW VPW VSS
X0 VSS a_1020_652# Q VPW nfet_06v0 ad=0.5808p pd=3.52u as=0.5808p ps=3.52u w=1.32u l=0.6u
X1 a_504_110# a_36_92# VDD VNW pfet_06v0 ad=0.44p pd=2.88u as=0.476p ps=2.18u w=1u l=0.5u
X2 VDD a_1020_652# Q VNW pfet_06v0 ad=0.8052p pd=4.54u as=0.8052p ps=4.54u w=1.83u l=0.5u
X3 a_1264_107# a_36_92# a_1020_652# VPW nfet_06v0 ad=0.263p pd=1.49u as=0.182p ps=1.22u w=0.7u l=0.6u
X4 VSS E a_36_92# VPW nfet_06v0 ad=0.263p pd=1.49u as=0.3476p ps=2.46u w=0.79u l=0.6u
X5 VSS a_1364_532# a_1264_107# VPW nfet_06v0 ad=0.2054p pd=1.31u as=0.263p ps=1.49u w=0.79u l=0.6u
X6 VDD E a_36_92# VNW pfet_06v0 ad=0.476p pd=2.18u as=0.6072p ps=3.64u w=1.38u l=0.5u
X7 VDD a_1364_532# a_1224_652# VNW pfet_06v0 ad=0.3588p pd=1.9u as=0.426p ps=2.08u w=1.38u l=0.5u
X8 a_872_652# D VDD VNW pfet_06v0 ad=0.12p pd=1.24u as=0.44p ps=2.88u w=1u l=0.5u
X9 a_1364_532# a_1020_652# VDD VNW pfet_06v0 ad=0.6072p pd=3.64u as=0.3588p ps=1.9u w=1.38u l=0.5u
X10 a_1020_652# a_504_110# a_872_107# VPW nfet_06v0 ad=0.182p pd=1.22u as=83.99999f ps=0.94u w=0.7u l=0.6u
X11 a_872_107# D VSS VPW nfet_06v0 ad=83.99999f pd=0.94u as=0.308p ps=2.28u w=0.7u l=0.6u
X12 a_1020_652# a_36_92# a_872_652# VNW pfet_06v0 ad=0.26p pd=1.52u as=0.12p ps=1.24u w=1u l=0.5u
X13 a_504_110# a_36_92# VSS VPW nfet_06v0 ad=0.308p pd=2.28u as=0.263p ps=1.49u w=0.7u l=0.6u
X14 a_1364_532# a_1020_652# VSS VPW nfet_06v0 ad=0.3476p pd=2.46u as=0.2054p ps=1.31u w=0.79u l=0.6u
X15 a_1224_652# a_504_110# a_1020_652# VNW pfet_06v0 ad=0.426p pd=2.08u as=0.26p ps=1.52u w=1u l=0.5u
.ends

.subckt gf180mcu_fd_sc_mcu9t5v0__inv_1 I ZN VDD VNW VPW VSS
X0 ZN I VDD VNW pfet_06v0 ad=0.8052p pd=4.54u as=0.8052p ps=4.54u w=1.83u l=0.5u
X1 ZN I VSS VPW nfet_06v0 ad=0.5808p pd=3.52u as=0.5808p ps=3.52u w=1.32u l=0.6u
.ends

.subckt gf180mcu_fd_sc_mcu9t5v0__and2_1 A1 A2 Z VDD VNW VPW VSS
X0 VDD A2 a_36_201# VNW pfet_06v0 ad=0.5054p pd=2.57u as=0.2132p ps=1.34u w=0.82u l=0.5u
X1 a_244_201# A1 a_36_201# VPW nfet_06v0 ad=0.1056p pd=0.98u as=0.2904p ps=2.2u w=0.66u l=0.6u
X2 Z a_36_201# VSS VPW nfet_06v0 ad=0.5808p pd=3.52u as=0.3894p ps=2.06u w=1.32u l=0.6u
X3 Z a_36_201# VDD VNW pfet_06v0 ad=0.8052p pd=4.54u as=0.5054p ps=2.57u w=1.83u l=0.5u
X4 VSS A2 a_244_201# VPW nfet_06v0 ad=0.3894p pd=2.06u as=0.1056p ps=0.98u w=0.66u l=0.6u
X5 a_36_201# A1 VDD VNW pfet_06v0 ad=0.2132p pd=1.34u as=0.3608p ps=2.52u w=0.82u l=0.5u
.ends

.subckt switch-cell VDD VSS RSTN CLK1 CLK2 D Q IN OUT
Xtrans-gate_0 trans-gate_0/SWP IN OUT VDD VSS trans-gate_0/SWN trans-gate
Xgf180mcu_fd_sc_mcu9t5v0__latq_1_0 D CLK1 gf180mcu_fd_sc_mcu9t5v0__latq_1_1/D VDD
+ VDD VSS VSS gf180mcu_fd_sc_mcu9t5v0__latq_1
Xgf180mcu_fd_sc_mcu9t5v0__latq_1_1 gf180mcu_fd_sc_mcu9t5v0__latq_1_1/D CLK2 Q VDD
+ VDD VSS VSS gf180mcu_fd_sc_mcu9t5v0__latq_1
Xgf180mcu_fd_sc_mcu9t5v0__inv_1_0 trans-gate_0/SWN trans-gate_0/SWP VDD VDD VSS VSS
+ gf180mcu_fd_sc_mcu9t5v0__inv_1
Xgf180mcu_fd_sc_mcu9t5v0__and2_1_0 Q RSTN trans-gate_0/SWN VDD VDD VSS VSS gf180mcu_fd_sc_mcu9t5v0__and2_1
.ends
