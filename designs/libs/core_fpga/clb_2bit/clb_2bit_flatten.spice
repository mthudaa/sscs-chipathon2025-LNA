* NGSPICE file created from clb_2bit_flatten.ext - technology: gf180mcuD

.subckt clb_2bit_flatten VDDd VSSd D CLK1 CLK2 Q CLK1_BUFF CLK2_BUFF OUT IN[1] IN[0]
+ CLK_CLB
X0 a_990_1479# IN[0].t0 a_746_939# VSSd.t76 nfet_05v0 ad=43.2f pd=0.6u as=93.59999f ps=0.88u w=0.36u l=0.6u
X1 VSSd.t188 a_1666_110# lut_0.gf180mcu_fd_sc_mcu7t5v0__mux2_1_3.Z VSSd.t187 nfet_05v0 ad=0.218p pd=1.52u as=0.3608p ps=2.52u w=0.82u l=0.6u
X2 a_210_n1839# a_1062_n1926# a_922_n1661# VSSd.t49 nfet_05v0 ad=0.1027p pd=0.915u as=0.15225p ps=1.165u w=0.395u l=0.6u
X3 a_210_n4975# a_1062_n5062# a_922_n4797# VSSd.t116 nfet_05v0 ad=0.1027p pd=0.915u as=0.15225p ps=1.165u w=0.395u l=0.6u
X4 a_982_190# a_678_493# a_210_110# VSSd.t102 nfet_05v0 ad=43.2f pd=0.6u as=93.59999f ps=0.88u w=0.36u l=0.6u
X5 VSSd.t46 a_1106_n892# lut_0.REG[4] VSSd.t12 nfet_05v0 ad=0.3608p pd=2.52u as=0.3608p ps=2.52u w=0.82u l=0.6u
X6 VDDd.t195 gf180mcu_fd_sc_mcu7t5v0__mux2_1_0.I1 a_2404_939# VDDd.t194 pfet_05v0 ad=0.42982p pd=2.185u as=84.55f ps=0.89u w=0.615u l=0.5u
X7 VDDd.t6 a_1062_n358# a_1102_n674# VDDd.t5 pfet_05v0 ad=0.32375p pd=1.72u as=0.3375p ps=2.33u w=0.625u l=0.5u
X8 VSSd.t146 a_1490_n7712# a_1350_n7668# VSSd.t145 nfet_05v0 ad=0.1209p pd=0.985u as=0.15225p ps=1.165u w=0.465u l=0.6u
X9 VDDd.t135 lut_0.gf180mcu_fd_sc_mcu7t5v0__mux2_1_2.Z a_950_939# VDDd.t134 pfet_05v0 ad=0.42982p pd=2.185u as=84.55f ps=0.89u w=0.615u l=0.5u
X10 reg_bank_5bit_0.gf180mcu_fd_sc_mcu7t5v0__latq_1_5.D a_210_n4975# VSSd.t199 VSSd.t148 nfet_05v0 ad=0.3608p pd=2.52u as=0.3608p ps=2.52u w=0.82u l=0.6u
X11 VSSd.t75 IN[0].t1 a_166_1479# VSSd.t74 nfet_05v0 ad=93.59999f pd=0.88u as=0.1584p ps=1.6u w=0.36u l=0.6u
X12 a_1490_n1440# a_1106_n892# VSSd.t45 VSSd.t44 nfet_05v0 ad=0.2046p pd=1.81u as=0.1209p ps=0.985u w=0.465u l=0.6u
X13 a_922_n3766# a_490_n3229# VDDd.t15 VDDd.t14 pfet_05v0 ad=0.372p pd=1.825u as=0.28675p ps=1.545u w=0.925u l=0.5u
X14 a_534_2127# a_122_1806.t2 VSSd.t173 VSSd.t172 nfet_05v0 ad=0.1782p pd=1.69u as=0.1053p ps=0.925u w=0.405u l=0.6u
X15 a_1062_n3494# CLK1.t0 VDDd.t93 VDDd.t92 pfet_05v0 ad=0.4048p pd=2.72u as=0.32375p ps=1.72u w=0.92u l=0.5u
X16 VDDd.t56 a_1490_n4576# a_1310_n4028# VDDd.t55 pfet_05v0 ad=0.28675p pd=1.545u as=0.372p ps=1.825u w=0.925u l=0.5u
X17 VSSd.t186 a_210_n6543# a_490_n6365# VSSd.t185 nfet_05v0 ad=0.1209p pd=0.985u as=0.2046p ps=1.81u w=0.465u l=0.6u
X18 CLK2_BUFF.t0 gf180mcu_fd_sc_mcu7t5v0__inv_1_0.ZN VDDd.t119 VDDd.t118 pfet_05v0 ad=0.5368p pd=3.32u as=0.5368p ps=3.32u w=1.22u l=0.5u
X19 VDDd.t149 lut_0.REG[2] a_982_679# VDDd.t148 pfet_05v0 ad=0.1599p pd=1.135u as=73.8f ps=0.855u w=0.615u l=0.5u
X20 a_210_n271# a_1062_n358# a_922_n93# VSSd.t6 nfet_05v0 ad=0.1027p pd=0.915u as=0.15225p ps=1.165u w=0.395u l=0.6u
X21 VSSd.t171 a_210_n3407# a_490_n3229# VSSd.t170 nfet_05v0 ad=0.1209p pd=0.985u as=0.2046p ps=1.81u w=0.465u l=0.6u
X22 a_210_n3407# a_1102_n3810# a_922_n3766# VDDd.t136 pfet_05v0 ad=0.1638p pd=1.15u as=0.372p ps=1.825u w=0.63u l=0.5u
X23 a_922_n630# a_490_n93# VDDd.t126 VDDd.t59 pfet_05v0 ad=0.372p pd=1.825u as=0.28675p ps=1.545u w=0.925u l=0.5u
X24 a_570_n2459# a_122_n2963# VDDd.t20 VDDd.t19 pfet_05v0 ad=0.3375p pd=2.33u as=0.32375p ps=1.72u w=0.625u l=0.5u
X25 a_570_n5595# a_122_n6099# VDDd.t76 VDDd.t75 pfet_05v0 ad=0.3375p pd=2.33u as=0.32375p ps=1.72u w=0.625u l=0.5u
X26 a_1106_n4028# a_570_n4027# a_958_n4532# VSSd.t147 nfet_05v0 ad=0.1027p pd=0.915u as=47.4f ps=0.635u w=0.395u l=0.6u
X27 gf180mcu_fd_sc_mcu7t5v0__inv_1_0.ZN CLK2.t0 VSSd.t37 VSSd.t36 nfet_05v0 ad=0.3608p pd=2.52u as=0.3608p ps=2.52u w=0.82u l=0.6u
X28 a_2134_493# IN[1].t0 VSSd.t160 VSSd.t159 nfet_05v0 ad=0.1584p pd=1.6u as=93.59999f ps=0.88u w=0.36u l=0.6u
X29 a_1406_n5334# a_1062_n5062# a_210_n4975# VDDd.t113 pfet_05v0 ad=75.59999f pd=0.87u as=0.1638p ps=1.15u w=0.63u l=0.5u
X30 VDDd.t51 a_1062_n1926# a_1102_n2242# VDDd.t44 pfet_05v0 ad=0.32375p pd=1.72u as=0.3375p ps=2.33u w=0.625u l=0.5u
X31 reg_bank_5bit_0.gf180mcu_fd_sc_mcu7t5v0__inv_1_0.ZN gf180mcu_fd_sc_mcu7t5v0__mux2_1_0.S VDDd.t133 VDDd.t132 pfet_05v0 ad=0.5368p pd=3.32u as=0.5368p ps=3.32u w=1.22u l=0.5u
X32 gf180mcu_fd_sc_mcu7t5v0__inv_1_3.ZN CLK1.t1 VDDd.t64 VDDd.t63 pfet_05v0 ad=0.5368p pd=3.32u as=0.5368p ps=3.32u w=1.22u l=0.5u
X33 VDDd.t29 a_1490_n1440# a_1310_n892# VDDd.t28 pfet_05v0 ad=0.28675p pd=1.545u as=0.372p ps=1.825u w=0.925u l=0.5u
X34 a_958_n4532# reg_bank_5bit_0.gf180mcu_fd_sc_mcu7t5v0__latq_1_8.D VSSd.t166 VSSd.t165 nfet_05v0 ad=47.4f pd=0.635u as=0.1738p ps=1.67u w=0.395u l=0.6u
X35 VSSd.t164 a_1106_n5596# lut_0.REG[1] VSSd.t81 nfet_05v0 ad=0.3608p pd=2.52u as=0.3608p ps=2.52u w=0.82u l=0.6u
X36 a_2444_1479# gf180mcu_fd_sc_mcu7t5v0__mux2_1_0.S a_2200_939# VSSd.t140 nfet_05v0 ad=43.2f pd=0.6u as=93.59999f ps=0.88u w=0.36u l=0.6u
X37 a_1406_n1647# a_1102_n2242# a_210_n1839# VSSd.t113 nfet_05v0 ad=47.4f pd=0.635u as=0.1027p ps=0.915u w=0.395u l=0.6u
X38 a_1490_n6144# a_1106_n5596# VSSd.t163 VSSd.t162 nfet_05v0 ad=0.2046p pd=1.81u as=0.1209p ps=0.985u w=0.465u l=0.6u
X39 a_958_n5596# reg_bank_5bit_0.gf180mcu_fd_sc_mcu7t5v0__latq_1_5.D VDDd.t186 VDDd.t185 pfet_05v0 ad=75.59999f pd=0.87u as=0.2772p ps=2.14u w=0.63u l=0.5u
X40 a_1406_n4783# a_1102_n5378# a_210_n4975# VSSd.t22 nfet_05v0 ad=47.4f pd=0.635u as=0.1027p ps=0.915u w=0.395u l=0.6u
X41 a_2097_2182# a_122_1806.t3 a_1462_1770# VDDd.t86 pfet_05v0 ad=0.1665p pd=1.285u as=0.1791p ps=1.355u w=0.36u l=0.5u
X42 VSSd.t29 CLK_CLB.t0 a_122_1806.t0 VSSd.t28 nfet_05v0 ad=0.1053p pd=0.925u as=0.1782p ps=1.69u w=0.405u l=0.6u
X43 a_958_n2460# reg_bank_5bit_0.gf180mcu_fd_sc_mcu7t5v0__latq_1_0.D VDDd.t81 VDDd.t18 pfet_05v0 ad=75.59999f pd=0.87u as=0.2772p ps=2.14u w=0.63u l=0.5u
X44 a_958_n892# reg_bank_5bit_0.gf180mcu_fd_sc_mcu7t5v0__latq_1_3.D VDDd.t54 VDDd.t53 pfet_05v0 ad=75.59999f pd=0.87u as=0.2772p ps=2.14u w=0.63u l=0.5u
X45 a_570_n2459# a_122_n2963# VSSd.t18 VSSd.t17 nfet_05v0 ad=0.1716p pd=1.66u as=0.1505p ps=1.16u w=0.39u l=0.6u
X46 a_1434_2182# a_122_1806.t4 a_1090_1814# VDDd.t168 pfet_05v0 ad=43.2f pd=0.6u as=0.1872p ps=1.4u w=0.36u l=0.5u
X47 VDDd.t60 a_210_n271# a_490_n93# VDDd.t59 pfet_05v0 ad=0.28675p pd=1.545u as=0.407p ps=2.73u w=0.925u l=0.5u
X48 VDDd.t41 D.t0 a_1406_n630# VDDd.t5 pfet_05v0 ad=0.2772p pd=2.14u as=75.59999f ps=0.87u w=0.63u l=0.5u
X49 a_922_n1661# a_490_n1661# VSSd.t80 VSSd.t79 nfet_05v0 ad=0.15225p pd=1.165u as=0.1209p ps=0.985u w=0.465u l=0.6u
X50 a_678_493# IN[1].t1 VDDd.t33 VDDd.t32 pfet_05v0 ad=0.2706p pd=2.11u as=0.1599p ps=1.135u w=0.615u l=0.5u
X51 a_1350_n1396# a_122_n1395# a_1106_n892# VSSd.t93 nfet_05v0 ad=0.15225p pd=1.165u as=0.1027p ps=0.915u w=0.395u l=0.6u
X52 VSSd.t149 CLK2.t1 a_122_n4531# VSSd.t148 nfet_05v0 ad=0.1505p pd=1.16u as=0.2024p ps=1.8u w=0.46u l=0.6u
X53 VSSd.t3 a_1462_1770# a_1414_1814# VSSd.t2 nfet_05v0 ad=0.2637p pd=1.825u as=43.2f ps=0.6u w=0.36u l=0.6u
X54 VDDd.t108 a_1106_n2460# lut_0.REG[3] VDDd.t107 pfet_05v0 ad=0.5368p pd=3.32u as=0.5368p ps=3.32u w=1.22u l=0.5u
X55 VDDd.t96 a_1062_n6630# a_1102_n6946# VDDd.t95 pfet_05v0 ad=0.32375p pd=1.72u as=0.3375p ps=2.33u w=0.625u l=0.5u
X56 VDDd.t192 a_210_n4975# a_490_n4797# VDDd.t191 pfet_05v0 ad=0.28675p pd=1.545u as=0.407p ps=2.73u w=0.925u l=0.5u
X57 gf180mcu_fd_sc_mcu7t5v0__mux2_1_0.I1 a_2390_1770# VSSd.t120 VSSd.t119 nfet_05v0 ad=0.3608p pd=2.52u as=0.3608p ps=2.52u w=0.82u l=0.6u
X58 a_1666_110# a_2134_493# a_2079_679# VDDd.t73 pfet_05v0 ad=0.1599p pd=1.135u as=84.55f ps=0.89u w=0.615u l=0.5u
X59 a_570_n891# a_122_n1395# VDDd.t91 VDDd.t90 pfet_05v0 ad=0.3375p pd=2.33u as=0.32375p ps=1.72u w=0.625u l=0.5u
X60 a_2200_939# a_1620_1479# a_2052_1479# VSSd.t200 nfet_05v0 ad=93.59999f pd=0.88u as=43.2f ps=0.6u w=0.36u l=0.6u
X61 VSSd.t48 a_1062_n1926# a_1102_n2242# VSSd.t47 nfet_05v0 ad=0.1505p pd=1.16u as=0.1716p ps=1.66u w=0.39u l=0.6u
X62 VSSd.t115 a_1062_n5062# a_1102_n5378# VSSd.t114 nfet_05v0 ad=0.1505p pd=1.16u as=0.1716p ps=1.66u w=0.39u l=0.6u
X63 gf180mcu_fd_sc_mcu7t5v0__mux2_1_0.I1 a_2390_1770# VDDd.t117 VDDd.t116 pfet_05v0 ad=0.5368p pd=3.32u as=0.5368p ps=3.32u w=1.22u l=0.5u
X64 VSSd.t43 lut_0.REG[4] a_2438_190# VSSd.t42 nfet_05v0 ad=93.59999f pd=0.88u as=43.2f ps=0.6u w=0.36u l=0.6u
X65 a_570_n7163# a_122_n7667# VSSd.t35 VSSd.t34 nfet_05v0 ad=0.1716p pd=1.66u as=0.1505p ps=1.16u w=0.39u l=0.6u
X66 a_623_679# lut_0.REG[1] VDDd.t123 VDDd.t122 pfet_05v0 ad=84.55f pd=0.89u as=0.42982p ps=2.185u w=0.615u l=0.5u
X67 OUT.t1 a_2200_939# VSSd.t20 VSSd.t19 nfet_05v0 ad=0.3608p pd=2.52u as=0.218p ps=1.52u w=0.82u l=0.6u
X68 VSSd.t158 lut_0.REG[2] a_1406_n4783# VSSd.t157 nfet_05v0 ad=0.1738p pd=1.67u as=47.4f ps=0.635u w=0.395u l=0.6u
X69 a_1414_1814# a_534_2127# a_1090_1814# VSSd.t1 nfet_05v0 ad=43.2f pd=0.6u as=0.207p ps=1.51u w=0.36u l=0.6u
X70 VSSd.t41 lut_0.REG[4] a_1406_n1647# VSSd.t40 nfet_05v0 ad=0.1738p pd=1.67u as=47.4f ps=0.635u w=0.395u l=0.6u
X71 a_922_n3229# a_490_n3229# VSSd.t15 VSSd.t14 nfet_05v0 ad=0.15225p pd=1.165u as=0.1209p ps=0.985u w=0.465u l=0.6u
X72 a_1490_n7712# a_1106_n7164# VDDd.t85 VDDd.t84 pfet_05v0 ad=0.407p pd=2.73u as=0.28675p ps=1.545u w=0.925u l=0.5u
X73 a_922_n6365# a_490_n6365# VSSd.t39 VSSd.t38 nfet_05v0 ad=0.15225p pd=1.165u as=0.1209p ps=0.985u w=0.465u l=0.6u
X74 a_746_939# IN[0].t2 a_598_939# VDDd.t79 pfet_05v0 ad=0.1599p pd=1.135u as=73.8f ps=0.855u w=0.615u l=0.5u
X75 VDDd.t27 CLK2.t2 a_122_n2963# VDDd.t26 pfet_05v0 ad=0.32375p pd=1.72u as=0.4048p ps=2.72u w=0.92u l=0.5u
X76 VDDd.t88 CLK2.t3 a_122_n6099# VDDd.t87 pfet_05v0 ad=0.32375p pd=1.72u as=0.4048p ps=2.72u w=0.92u l=0.5u
X77 a_1350_n6100# a_122_n6099# a_1106_n5596# VSSd.t73 nfet_05v0 ad=0.15225p pd=1.165u as=0.1027p ps=0.915u w=0.395u l=0.6u
X78 VSSd.t202 gf180mcu_fd_sc_mcu7t5v0__mux2_1_0.I1 a_2444_1479# VSSd.t201 nfet_05v0 ad=0.218p pd=1.52u as=43.2f ps=0.6u w=0.36u l=0.6u
X79 VSSd.t150 a_210_110# lut_0.gf180mcu_fd_sc_mcu7t5v0__mux2_1_2.Z VSSd.t54 nfet_05v0 ad=0.218p pd=1.52u as=0.3608p ps=2.52u w=0.82u l=0.6u
X80 a_1106_n892# a_570_n891# a_958_n1396# VSSd.t111 nfet_05v0 ad=0.1027p pd=0.915u as=47.4f ps=0.635u w=0.395u l=0.6u
X81 VSSd.t53 a_1490_n4576# a_1350_n4532# VSSd.t52 nfet_05v0 ad=0.1209p pd=0.985u as=0.15225p ps=1.165u w=0.465u l=0.6u
X82 reg_bank_5bit_0.gf180mcu_fd_sc_mcu7t5v0__latq_1_0.D a_210_n1839# VSSd.t63 VSSd.t62 nfet_05v0 ad=0.3608p pd=2.52u as=0.3608p ps=2.52u w=0.82u l=0.6u
X83 a_2382_2182# a_534_2127# a_2097_2182# VDDd.t2 pfet_05v0 ad=50.4f pd=0.64u as=0.1665p ps=1.285u w=0.36u l=0.5u
X84 a_1406_n2198# a_1062_n1926# a_210_n1839# VDDd.t44 pfet_05v0 ad=75.59999f pd=0.87u as=0.1638p ps=1.15u w=0.63u l=0.5u
X85 a_2390_1770# a_2097_2182# VDDd.t13 VDDd.t12 pfet_05v0 ad=0.352p pd=2.48u as=0.23p ps=1.54u w=0.8u l=0.5u
X86 reg_bank_5bit_0.gf180mcu_fd_sc_mcu7t5v0__latq_1_5.D a_210_n4975# VDDd.t190 VDDd.t189 pfet_05v0 ad=0.5368p pd=3.32u as=0.5368p ps=3.32u w=1.22u l=0.5u
X87 a_2438_679# IN[1].t2 a_1666_110# VDDd.t34 pfet_05v0 ad=73.8f pd=0.855u as=0.1599p ps=1.135u w=0.615u l=0.5u
X88 a_958_n1396# reg_bank_5bit_0.gf180mcu_fd_sc_mcu7t5v0__latq_1_3.D VSSd.t51 VSSd.t50 nfet_05v0 ad=47.4f pd=0.635u as=0.1738p ps=1.67u w=0.395u l=0.6u
X89 a_1310_n7164# a_570_n7163# a_1106_n7164# VDDd.t23 pfet_05v0 ad=0.372p pd=1.825u as=0.1638p ps=1.15u w=0.63u l=0.5u
X90 CLK2_BUFF.t1 gf180mcu_fd_sc_mcu7t5v0__inv_1_0.ZN VSSd.t122 VSSd.t121 nfet_05v0 ad=0.3608p pd=2.52u as=0.3608p ps=2.52u w=0.82u l=0.6u
X91 a_1310_n4028# a_570_n4027# a_1106_n4028# VDDd.t141 pfet_05v0 ad=0.372p pd=1.825u as=0.1638p ps=1.15u w=0.63u l=0.5u
X92 a_950_939# a_166_1479# a_746_939# VDDd.t25 pfet_05v0 ad=84.55f pd=0.89u as=0.1599p ps=1.135u w=0.615u l=0.5u
X93 VDDd.t147 lut_0.REG[2] a_1406_n5334# VDDd.t146 pfet_05v0 ad=0.2772p pd=2.14u as=75.59999f ps=0.87u w=0.63u l=0.5u
X94 a_2390_1770# a_2097_2182# VSSd.t11 VSSd.t10 nfet_05v0 ad=0.176p pd=1.68u as=0.142p ps=1.14u w=0.4u l=0.6u
X95 a_1490_n3008# a_1106_n2460# VSSd.t110 VSSd.t109 nfet_05v0 ad=0.2046p pd=1.81u as=0.1209p ps=0.985u w=0.465u l=0.6u
X96 a_1406_n630# a_1062_n358# a_210_n271# VDDd.t5 pfet_05v0 ad=75.59999f pd=0.87u as=0.1638p ps=1.15u w=0.63u l=0.5u
X97 a_1310_n892# a_570_n891# a_1106_n892# VDDd.t53 pfet_05v0 ad=0.372p pd=1.825u as=0.1638p ps=1.15u w=0.63u l=0.5u
X98 a_210_n3407# a_1062_n3494# a_922_n3229# VSSd.t9 nfet_05v0 ad=0.1027p pd=0.915u as=0.15225p ps=1.165u w=0.395u l=0.6u
X99 a_210_n6543# a_1062_n6630# a_922_n6365# VSSd.t96 nfet_05v0 ad=0.1027p pd=0.915u as=0.15225p ps=1.165u w=0.395u l=0.6u
X100 VDDd.t157 a_1490_n3008# a_1310_n2460# VDDd.t26 pfet_05v0 ad=0.28675p pd=1.545u as=0.372p ps=1.825u w=0.925u l=0.5u
X101 VDDd.t105 a_1490_n6144# a_1310_n5596# VDDd.t104 pfet_05v0 ad=0.28675p pd=1.545u as=0.372p ps=1.825u w=0.925u l=0.5u
X102 VDDd.t47 lut_0.REG[4] a_2438_679# VDDd.t46 pfet_05v0 ad=0.1599p pd=1.135u as=73.8f ps=0.855u w=0.615u l=0.5u
X103 a_1106_n5596# a_570_n5595# a_958_n6100# VSSd.t161 nfet_05v0 ad=0.1027p pd=0.915u as=47.4f ps=0.635u w=0.395u l=0.6u
X104 VDDd.t110 CLK_CLB.t1 a_122_1806.t1 VDDd.t109 pfet_05v0 ad=0.2249p pd=1.385u as=0.3806p ps=2.61u w=0.865u l=0.5u
X105 reg_bank_5bit_0.gf180mcu_fd_sc_mcu7t5v0__latq_1_6.Q a_210_n6543# VSSd.t184 VSSd.t67 nfet_05v0 ad=0.3608p pd=2.52u as=0.3608p ps=2.52u w=0.82u l=0.6u
X106 VSSd.t69 CLK2.t4 a_122_n1395# VSSd.t62 nfet_05v0 ad=0.1505p pd=1.16u as=0.2024p ps=1.8u w=0.46u l=0.6u
X107 a_1406_n6902# a_1062_n6630# a_210_n6543# VDDd.t94 pfet_05v0 ad=75.59999f pd=0.87u as=0.1638p ps=1.15u w=0.63u l=0.5u
X108 a_1062_n5062# CLK1.t2 VDDd.t128 VDDd.t127 pfet_05v0 ad=0.4048p pd=2.72u as=0.32375p ps=1.72u w=0.92u l=0.5u
X109 a_922_n5334# a_490_n4797# VDDd.t125 VDDd.t124 pfet_05v0 ad=0.372p pd=1.825u as=0.28675p ps=1.545u w=0.925u l=0.5u
X110 VDDd.t131 gf180mcu_fd_sc_mcu7t5v0__mux2_1_0.S a_1620_1479# VDDd.t130 pfet_05v0 ad=0.1599p pd=1.135u as=0.2706p ps=2.11u w=0.615u l=0.5u
X111 a_210_110# IN[1].t3 a_590_190# VSSd.t101 nfet_05v0 ad=93.59999f pd=0.88u as=43.2f ps=0.6u w=0.36u l=0.6u
X112 gf180mcu_fd_sc_mcu7t5v0__inv_1_0.ZN CLK2.t5 VDDd.t145 VDDd.t144 pfet_05v0 ad=0.5368p pd=3.32u as=0.5368p ps=3.32u w=1.22u l=0.5u
X113 VDDd.t9 a_1062_n3494# a_1102_n3810# VDDd.t8 pfet_05v0 ad=0.32375p pd=1.72u as=0.3375p ps=2.33u w=0.625u l=0.5u
X114 a_922_n93# a_490_n93# VSSd.t130 VSSd.t129 nfet_05v0 ad=0.15225p pd=1.165u as=0.1209p ps=0.985u w=0.465u l=0.6u
X115 VDDd.t70 a_210_n1839# a_490_n1661# VDDd.t69 pfet_05v0 ad=0.28675p pd=1.545u as=0.407p ps=2.73u w=0.925u l=0.5u
X116 a_958_n6100# reg_bank_5bit_0.gf180mcu_fd_sc_mcu7t5v0__latq_1_5.D VSSd.t192 VSSd.t191 nfet_05v0 ad=47.4f pd=0.635u as=0.1738p ps=1.67u w=0.395u l=0.6u
X117 a_210_n4975# a_1102_n5378# a_922_n5334# VDDd.t24 pfet_05v0 ad=0.1638p pd=1.15u as=0.372p ps=1.825u w=0.63u l=0.5u
X118 VSSd.t132 D.t1 a_1406_n79# VSSd.t131 nfet_05v0 ad=0.1738p pd=1.67u as=47.4f ps=0.635u w=0.395u l=0.6u
X119 a_570_n7163# a_122_n7667# VDDd.t40 VDDd.t39 pfet_05v0 ad=0.3375p pd=2.33u as=0.32375p ps=1.72u w=0.625u l=0.5u
X120 a_570_n4027# a_122_n4531# VDDd.t176 VDDd.t175 pfet_05v0 ad=0.3375p pd=2.33u as=0.32375p ps=1.72u w=0.625u l=0.5u
X121 a_922_1814# a_122_1806.t5 VSSd.t152 VSSd.t151 nfet_05v0 ad=43.2f pd=0.6u as=0.1584p ps=1.6u w=0.36u l=0.6u
X122 a_2134_493# IN[1].t4 VDDd.t11 VDDd.t10 pfet_05v0 ad=0.2706p pd=2.11u as=0.1599p ps=1.135u w=0.615u l=0.5u
X123 a_1490_n7712# a_1106_n7164# VSSd.t88 VSSd.t87 nfet_05v0 ad=0.2046p pd=1.81u as=0.1209p ps=0.985u w=0.465u l=0.6u
X124 a_2052_939# lut_0.LUT_OUT VDDd.t37 VDDd.t36 pfet_05v0 ad=73.8f pd=0.855u as=0.1599p ps=1.135u w=0.615u l=0.5u
X125 a_678_493# IN[1].t5 VSSd.t134 VSSd.t133 nfet_05v0 ad=0.1584p pd=1.6u as=93.59999f ps=0.88u w=0.36u l=0.6u
X126 a_1490_n4576# a_1106_n4028# VDDd.t100 VDDd.t99 pfet_05v0 ad=0.407p pd=2.73u as=0.28675p ps=1.545u w=0.925u l=0.5u
X127 a_2046_190# lut_0.REG[3] VSSd.t177 VSSd.t176 nfet_05v0 ad=43.2f pd=0.6u as=0.218p ps=1.52u w=0.36u l=0.6u
X128 a_1406_n3215# a_1102_n3810# a_210_n3407# VSSd.t144 nfet_05v0 ad=47.4f pd=0.635u as=0.1027p ps=0.915u w=0.395u l=0.6u
X129 a_958_n7164# reg_bank_5bit_0.gf180mcu_fd_sc_mcu7t5v0__latq_1_6.Q VDDd.t188 VDDd.t187 pfet_05v0 ad=75.59999f pd=0.87u as=0.2772p ps=2.14u w=0.63u l=0.5u
X130 a_1406_n6351# a_1102_n6946# a_210_n6543# VSSd.t178 nfet_05v0 ad=47.4f pd=0.635u as=0.1027p ps=0.915u w=0.395u l=0.6u
X131 a_1062_n5062# CLK1.t3 VSSd.t196 VSSd.t99 nfet_05v0 ad=0.2024p pd=1.8u as=0.1505p ps=1.16u w=0.46u l=0.6u
X132 a_958_n4028# reg_bank_5bit_0.gf180mcu_fd_sc_mcu7t5v0__latq_1_8.D VDDd.t156 VDDd.t155 pfet_05v0 ad=75.59999f pd=0.87u as=0.2772p ps=2.14u w=0.63u l=0.5u
X133 a_1350_n2964# a_122_n2963# a_1106_n2460# VSSd.t16 nfet_05v0 ad=0.15225p pd=1.165u as=0.1027p ps=0.915u w=0.395u l=0.6u
X134 VSSd.t68 CLK2.t6 a_122_n6099# VSSd.t67 nfet_05v0 ad=0.1505p pd=1.16u as=0.2024p ps=1.8u w=0.46u l=0.6u
X135 VSSd.t25 a_1490_n1440# a_1350_n1396# VSSd.t24 nfet_05v0 ad=0.1209p pd=0.985u as=0.15225p ps=1.165u w=0.465u l=0.6u
X136 a_2097_2182# a_534_2127# a_1462_1770# VSSd.t0 nfet_05v0 ad=93.59999f pd=0.88u as=93.59999f ps=0.88u w=0.36u l=0.6u
X137 a_570_n4027# a_122_n4531# VSSd.t183 VSSd.t182 nfet_05v0 ad=0.1716p pd=1.66u as=0.1505p ps=1.16u w=0.39u l=0.6u
X138 VDDd.t180 a_210_n6543# a_490_n6365# VDDd.t179 pfet_05v0 ad=0.28675p pd=1.545u as=0.407p ps=2.73u w=0.925u l=0.5u
X139 a_210_110# a_678_493# a_623_679# VDDd.t103 pfet_05v0 ad=0.1599p pd=1.135u as=84.55f ps=0.89u w=0.615u l=0.5u
X140 reg_bank_5bit_0.gf180mcu_fd_sc_mcu7t5v0__latq_1_0.D a_210_n1839# VDDd.t68 VDDd.t67 pfet_05v0 ad=0.5368p pd=3.32u as=0.5368p ps=3.32u w=1.22u l=0.5u
X141 a_1106_n2460# a_122_n2963# a_958_n2460# VDDd.t18 pfet_05v0 ad=0.1638p pd=1.15u as=75.59999f ps=0.87u w=0.63u l=0.5u
X142 a_1106_n5596# a_122_n6099# a_958_n5596# VDDd.t74 pfet_05v0 ad=0.1638p pd=1.15u as=75.59999f ps=0.87u w=0.63u l=0.5u
X143 a_2200_939# gf180mcu_fd_sc_mcu7t5v0__mux2_1_0.S a_2052_939# VDDd.t129 pfet_05v0 ad=0.1599p pd=1.135u as=73.8f ps=0.855u w=0.615u l=0.5u
X144 a_590_190# lut_0.REG[1] VSSd.t126 VSSd.t125 nfet_05v0 ad=43.2f pd=0.6u as=0.218p ps=1.52u w=0.36u l=0.6u
X145 VSSd.t108 a_1106_n2460# lut_0.REG[3] VSSd.t107 nfet_05v0 ad=0.3608p pd=2.52u as=0.3608p ps=2.52u w=0.82u l=0.6u
X146 VDDd.t83 a_1106_n7164# gf180mcu_fd_sc_mcu7t5v0__mux2_1_0.S VDDd.t82 pfet_05v0 ad=0.5368p pd=3.32u as=0.5368p ps=3.32u w=1.22u l=0.5u
X147 VDDd.t98 a_1106_n4028# lut_0.REG[2] VDDd.t97 pfet_05v0 ad=0.5368p pd=3.32u as=0.5368p ps=3.32u w=1.22u l=0.5u
X148 a_1462_1770# a_1090_1814# VDDd.t72 VDDd.t71 pfet_05v0 ad=0.1791p pd=1.355u as=0.1044p ps=0.94u w=0.36u l=0.5u
X149 VDDd.t50 a_1106_n892# lut_0.REG[4] VDDd.t49 pfet_05v0 ad=0.5368p pd=3.32u as=0.5368p ps=3.32u w=1.22u l=0.5u
X150 VDDd.t45 lut_0.REG[4] a_1406_n2198# VDDd.t44 pfet_05v0 ad=0.2772p pd=2.14u as=75.59999f ps=0.87u w=0.63u l=0.5u
X151 VSSd.t143 lut_0.gf180mcu_fd_sc_mcu7t5v0__mux2_1_2.Z a_990_1479# VSSd.t142 nfet_05v0 ad=0.218p pd=1.52u as=43.2f ps=0.6u w=0.36u l=0.6u
X152 VSSd.t57 a_210_n271# a_490_n93# VSSd.t56 nfet_05v0 ad=0.1209p pd=0.985u as=0.2046p ps=1.81u w=0.465u l=0.6u
X153 VDDd.t182 a_1666_110# lut_0.gf180mcu_fd_sc_mcu7t5v0__mux2_1_3.Z VDDd.t181 pfet_05v0 ad=0.42982p pd=2.185u as=0.5368p ps=3.32u w=1.22u l=0.5u
X154 a_1106_n892# a_122_n1395# a_958_n892# VDDd.t53 pfet_05v0 ad=0.1638p pd=1.15u as=75.59999f ps=0.87u w=0.63u l=0.5u
X155 VSSd.t8 a_1062_n3494# a_1102_n3810# VSSd.t7 nfet_05v0 ad=0.1505p pd=1.16u as=0.1716p ps=1.66u w=0.39u l=0.6u
X156 VSSd.t95 a_1062_n6630# a_1102_n6946# VSSd.t94 nfet_05v0 ad=0.1505p pd=1.16u as=0.1716p ps=1.66u w=0.39u l=0.6u
X157 lut_0.LUT_OUT a_746_939# VDDd.t173 VDDd.t172 pfet_05v0 ad=0.5368p pd=3.32u as=0.42982p ps=2.185u w=1.22u l=0.5u
X158 a_982_679# IN[1].t6 a_210_110# VDDd.t89 pfet_05v0 ad=73.8f pd=0.855u as=0.1599p ps=1.135u w=0.615u l=0.5u
X159 a_1062_n358# CLK1.t4 VSSd.t106 VSSd.t105 nfet_05v0 ad=0.2024p pd=1.8u as=0.1505p ps=1.16u w=0.46u l=0.6u
X160 a_1350_n7668# a_122_n7667# a_1106_n7164# VSSd.t33 nfet_05v0 ad=0.15225p pd=1.165u as=0.1027p ps=0.915u w=0.395u l=0.6u
X161 VSSd.t198 a_210_n4975# a_490_n4797# VSSd.t197 nfet_05v0 ad=0.1209p pd=0.985u as=0.2046p ps=1.81u w=0.465u l=0.6u
X162 a_1090_1814# lut_0.LUT_OUT a_922_1814# VSSd.t32 nfet_05v0 ad=0.207p pd=1.51u as=43.2f ps=0.6u w=0.36u l=0.6u
X163 a_1462_1770# a_1090_1814# VSSd.t66 VSSd.t65 nfet_05v0 ad=93.59999f pd=0.88u as=0.2637p ps=1.825u w=0.36u l=0.6u
X164 a_1406_n79# a_1102_n674# a_210_n271# VSSd.t135 nfet_05v0 ad=47.4f pd=0.635u as=0.1027p ps=0.915u w=0.395u l=0.6u
X165 a_1106_n2460# a_570_n2459# a_958_n2964# VSSd.t64 nfet_05v0 ad=0.1027p pd=0.915u as=47.4f ps=0.635u w=0.395u l=0.6u
X166 VSSd.t104 a_1490_n6144# a_1350_n6100# VSSd.t103 nfet_05v0 ad=0.1209p pd=0.985u as=0.15225p ps=1.165u w=0.465u l=0.6u
X167 reg_bank_5bit_0.gf180mcu_fd_sc_mcu7t5v0__inv_1_0.ZN gf180mcu_fd_sc_mcu7t5v0__mux2_1_0.S VSSd.t139 VSSd.t138 nfet_05v0 ad=0.3608p pd=2.52u as=0.3608p ps=2.52u w=0.82u l=0.6u
X168 gf180mcu_fd_sc_mcu7t5v0__inv_1_3.ZN CLK1.t5 VSSd.t90 VSSd.t89 nfet_05v0 ad=0.3608p pd=2.52u as=0.3608p ps=2.52u w=0.82u l=0.6u
X169 a_1090_1814# lut_0.LUT_OUT a_966_2182# VDDd.t35 pfet_05v0 ad=0.1872p pd=1.4u as=54f ps=0.66u w=0.36u l=0.5u
X170 a_922_n2198# a_490_n1661# VDDd.t80 VDDd.t69 pfet_05v0 ad=0.372p pd=1.825u as=0.28675p ps=1.545u w=0.925u l=0.5u
X171 a_1062_n1926# CLK1.t6 VDDd.t66 VDDd.t65 pfet_05v0 ad=0.4048p pd=2.72u as=0.32375p ps=1.72u w=0.92u l=0.5u
X172 VSSd.t175 lut_0.REG[3] a_1406_n3215# VSSd.t174 nfet_05v0 ad=0.1738p pd=1.67u as=47.4f ps=0.635u w=0.395u l=0.6u
X173 VSSd.t124 lut_0.REG[1] a_1406_n6351# VSSd.t123 nfet_05v0 ad=0.1738p pd=1.67u as=47.4f ps=0.635u w=0.395u l=0.6u
X174 a_1406_n3766# a_1062_n3494# a_210_n3407# VDDd.t7 pfet_05v0 ad=75.59999f pd=0.87u as=0.1638p ps=1.15u w=0.63u l=0.5u
X175 VSSd.t5 a_1062_n358# a_1102_n674# VSSd.t4 nfet_05v0 ad=0.1505p pd=1.16u as=0.1716p ps=1.66u w=0.39u l=0.6u
X176 VDDd.t171 CLK2.t7 a_122_n7667# VDDd.t170 pfet_05v0 ad=0.32375p pd=1.72u as=0.4048p ps=2.72u w=0.92u l=0.5u
X177 reg_bank_5bit_0.gf180mcu_fd_sc_mcu7t5v0__latq_1_6.Q a_210_n6543# VDDd.t178 VDDd.t177 pfet_05v0 ad=0.5368p pd=3.32u as=0.5368p ps=3.32u w=1.22u l=0.5u
X178 a_2404_939# a_1620_1479# a_2200_939# VDDd.t193 pfet_05v0 ad=84.55f pd=0.89u as=0.1599p ps=1.135u w=0.615u l=0.5u
X179 a_2438_190# a_2134_493# a_1666_110# VSSd.t70 nfet_05v0 ad=43.2f pd=0.6u as=93.59999f ps=0.88u w=0.36u l=0.6u
X180 a_210_n1839# a_1102_n2242# a_922_n2198# VDDd.t44 pfet_05v0 ad=0.1638p pd=1.15u as=0.372p ps=1.825u w=0.63u l=0.5u
X181 Q.t0 reg_bank_5bit_0.gf180mcu_fd_sc_mcu7t5v0__inv_1_0.ZN VDDd.t62 VDDd.t61 pfet_05v0 ad=0.5368p pd=3.32u as=0.5368p ps=3.32u w=1.22u l=0.5u
X182 CLK1_BUFF.t0 gf180mcu_fd_sc_mcu7t5v0__inv_1_3.ZN VDDd.t31 VDDd.t30 pfet_05v0 ad=0.5368p pd=3.32u as=0.5368p ps=3.32u w=1.22u l=0.5u
X183 a_958_n2964# reg_bank_5bit_0.gf180mcu_fd_sc_mcu7t5v0__latq_1_0.D VSSd.t84 VSSd.t83 nfet_05v0 ad=47.4f pd=0.635u as=0.1738p ps=1.67u w=0.395u l=0.6u
X184 VSSd.t86 a_1106_n7164# gf180mcu_fd_sc_mcu7t5v0__mux2_1_0.S VSSd.t85 nfet_05v0 ad=0.3608p pd=2.52u as=0.3608p ps=2.52u w=0.82u l=0.6u
X185 VSSd.t100 a_1106_n4028# lut_0.REG[2] VSSd.t99 nfet_05v0 ad=0.3608p pd=2.52u as=0.3608p ps=2.52u w=0.82u l=0.6u
X186 reg_bank_5bit_0.gf180mcu_fd_sc_mcu7t5v0__latq_1_3.D a_210_n271# VDDd.t58 VDDd.t57 pfet_05v0 ad=0.5368p pd=3.32u as=0.5368p ps=3.32u w=1.22u l=0.5u
X187 VDDd.t121 lut_0.REG[1] a_1406_n6902# VDDd.t120 pfet_05v0 ad=0.2772p pd=2.14u as=75.59999f ps=0.87u w=0.63u l=0.5u
X188 a_1490_n1440# a_1106_n892# VDDd.t48 VDDd.t28 pfet_05v0 ad=0.407p pd=2.73u as=0.28675p ps=1.545u w=0.925u l=0.5u
X189 a_1106_n7164# a_570_n7163# a_958_n7668# VSSd.t21 nfet_05v0 ad=0.1027p pd=0.915u as=47.4f ps=0.635u w=0.395u l=0.6u
X190 a_1490_n4576# a_1106_n4028# VSSd.t98 VSSd.t97 nfet_05v0 ad=0.2046p pd=1.81u as=0.1209p ps=0.985u w=0.465u l=0.6u
X191 a_2342_1814# a_122_1806.t6 a_2097_2182# VSSd.t193 nfet_05v0 ad=43.2f pd=0.6u as=93.59999f ps=0.88u w=0.36u l=0.6u
X192 VDDd.t52 CLK2.t8 a_122_n1395# VDDd.t28 pfet_05v0 ad=0.32375p pd=1.72u as=0.4048p ps=2.72u w=0.92u l=0.5u
X193 a_570_n891# a_122_n1395# VSSd.t92 VSSd.t91 nfet_05v0 ad=0.1716p pd=1.66u as=0.1505p ps=1.16u w=0.39u l=0.6u
X194 VSSd.t78 CLK2.t9 a_122_n2963# VSSd.t77 nfet_05v0 ad=0.1505p pd=1.16u as=0.2024p ps=1.8u w=0.46u l=0.6u
X195 a_1062_n6630# CLK1.t7 VDDd.t138 VDDd.t137 pfet_05v0 ad=0.4048p pd=2.72u as=0.32375p ps=1.72u w=0.92u l=0.5u
X196 a_922_n6902# a_490_n6365# VDDd.t43 VDDd.t42 pfet_05v0 ad=0.372p pd=1.825u as=0.28675p ps=1.545u w=0.925u l=0.5u
X197 VDDd.t115 a_2390_1770# a_2382_2182# VDDd.t114 pfet_05v0 ad=0.23p pd=1.54u as=50.4f ps=0.64u w=0.36u l=0.5u
X198 VDDd.t140 a_1490_n7712# a_1310_n7164# VDDd.t139 pfet_05v0 ad=0.28675p pd=1.545u as=0.372p ps=1.825u w=0.925u l=0.5u
X199 VDDd.t161 a_210_n3407# a_490_n3229# VDDd.t160 pfet_05v0 ad=0.28675p pd=1.545u as=0.407p ps=2.73u w=0.925u l=0.5u
X200 a_958_n7668# reg_bank_5bit_0.gf180mcu_fd_sc_mcu7t5v0__latq_1_6.Q VSSd.t195 VSSd.t194 nfet_05v0 ad=47.4f pd=0.635u as=0.1738p ps=1.67u w=0.395u l=0.6u
X201 a_1062_n358# CLK1.t8 VDDd.t163 VDDd.t162 pfet_05v0 ad=0.4048p pd=2.72u as=0.32375p ps=1.72u w=0.92u l=0.5u
X202 a_210_n6543# a_1102_n6946# a_922_n6902# VDDd.t169 pfet_05v0 ad=0.1638p pd=1.15u as=0.372p ps=1.825u w=0.63u l=0.5u
X203 VSSd.t137 gf180mcu_fd_sc_mcu7t5v0__mux2_1_0.S a_1620_1479# VSSd.t136 nfet_05v0 ad=93.59999f pd=0.88u as=0.1584p ps=1.6u w=0.36u l=0.6u
X204 a_1062_n1926# CLK1.t9 VSSd.t13 VSSd.t12 nfet_05v0 ad=0.2024p pd=1.8u as=0.1505p ps=1.16u w=0.46u l=0.6u
X205 a_746_939# a_166_1479# a_598_1479# VSSd.t23 nfet_05v0 ad=93.59999f pd=0.88u as=43.2f ps=0.6u w=0.36u l=0.6u
X206 a_1666_110# IN[1].t7 a_2046_190# VSSd.t141 nfet_05v0 ad=93.59999f pd=0.88u as=43.2f ps=0.6u w=0.36u l=0.6u
X207 lut_0.LUT_OUT a_746_939# VSSd.t180 VSSd.t179 nfet_05v0 ad=0.3608p pd=2.52u as=0.218p ps=1.52u w=0.82u l=0.6u
X208 VDDd.t78 IN[0].t3 a_166_1479# VDDd.t77 pfet_05v0 ad=0.1599p pd=1.135u as=0.2706p ps=2.11u w=0.615u l=0.5u
X209 VDDd.t112 a_1062_n5062# a_1102_n5378# VDDd.t111 pfet_05v0 ad=0.32375p pd=1.72u as=0.3375p ps=2.33u w=0.625u l=0.5u
X210 OUT.t0 a_2200_939# VDDd.t22 VDDd.t21 pfet_05v0 ad=0.5368p pd=3.32u as=0.42982p ps=2.185u w=1.22u l=0.5u
X211 a_1490_n3008# a_1106_n2460# VDDd.t106 VDDd.t26 pfet_05v0 ad=0.407p pd=2.73u as=0.28675p ps=1.545u w=0.925u l=0.5u
X212 a_1490_n6144# a_1106_n5596# VDDd.t154 VDDd.t153 pfet_05v0 ad=0.407p pd=2.73u as=0.28675p ps=1.545u w=0.925u l=0.5u
X213 a_922_n4797# a_490_n4797# VSSd.t128 VSSd.t127 nfet_05v0 ad=0.15225p pd=1.165u as=0.1209p ps=0.985u w=0.465u l=0.6u
X214 reg_bank_5bit_0.gf180mcu_fd_sc_mcu7t5v0__latq_1_3.D a_210_n271# VSSd.t55 VSSd.t54 nfet_05v0 ad=0.3608p pd=2.52u as=0.3608p ps=2.52u w=0.82u l=0.6u
X215 VSSd.t154 CLK2.t10 a_122_n7667# VSSd.t153 nfet_05v0 ad=0.1505p pd=1.16u as=0.2024p ps=1.8u w=0.46u l=0.6u
X216 VSSd.t156 lut_0.REG[2] a_982_190# VSSd.t155 nfet_05v0 ad=93.59999f pd=0.88u as=43.2f ps=0.6u w=0.36u l=0.6u
X217 a_210_n271# a_1102_n674# a_922_n630# VDDd.t5 pfet_05v0 ad=0.1638p pd=1.15u as=0.372p ps=1.825u w=0.63u l=0.5u
X218 VSSd.t168 a_1490_n3008# a_1350_n2964# VSSd.t167 nfet_05v0 ad=0.1209p pd=0.985u as=0.15225p ps=1.165u w=0.465u l=0.6u
X219 a_570_n5595# a_122_n6099# VSSd.t72 VSSd.t71 nfet_05v0 ad=0.1716p pd=1.66u as=0.1505p ps=1.16u w=0.39u l=0.6u
X220 a_534_2127# a_122_1806.t7 VDDd.t102 VDDd.t101 pfet_05v0 ad=0.3806p pd=2.61u as=0.2249p ps=1.385u w=0.865u l=0.5u
X221 a_598_1479# lut_0.gf180mcu_fd_sc_mcu7t5v0__mux2_1_3.Z VSSd.t190 VSSd.t189 nfet_05v0 ad=43.2f pd=0.6u as=93.59999f ps=0.88u w=0.36u l=0.6u
X222 VDDd.t17 CLK2.t11 a_122_n4531# VDDd.t16 pfet_05v0 ad=0.32375p pd=1.72u as=0.4048p ps=2.72u w=0.92u l=0.5u
X223 VDDd.t4 a_1462_1770# a_1434_2182# VDDd.t3 pfet_05v0 ad=0.1044p pd=0.94u as=43.2f ps=0.6u w=0.36u l=0.5u
X224 reg_bank_5bit_0.gf180mcu_fd_sc_mcu7t5v0__latq_1_8.D a_210_n3407# VDDd.t159 VDDd.t158 pfet_05v0 ad=0.5368p pd=3.32u as=0.5368p ps=3.32u w=1.22u l=0.5u
X225 a_1062_n3494# CLK1.t10 VSSd.t112 VSSd.t107 nfet_05v0 ad=0.2024p pd=1.8u as=0.1505p ps=1.16u w=0.46u l=0.6u
X226 Q.t1 reg_bank_5bit_0.gf180mcu_fd_sc_mcu7t5v0__inv_1_0.ZN VSSd.t59 VSSd.t58 nfet_05v0 ad=0.3608p pd=2.52u as=0.3608p ps=2.52u w=0.82u l=0.6u
X227 a_1062_n6630# CLK1.t11 VSSd.t82 VSSd.t81 nfet_05v0 ad=0.2024p pd=1.8u as=0.1505p ps=1.16u w=0.46u l=0.6u
X228 a_1310_n5596# a_570_n5595# a_1106_n5596# VDDd.t150 pfet_05v0 ad=0.372p pd=1.825u as=0.1638p ps=1.15u w=0.63u l=0.5u
X229 CLK1_BUFF.t1 gf180mcu_fd_sc_mcu7t5v0__inv_1_3.ZN VSSd.t27 VSSd.t26 nfet_05v0 ad=0.3608p pd=2.52u as=0.3608p ps=2.52u w=0.82u l=0.6u
X230 VDDd.t143 a_210_110# lut_0.gf180mcu_fd_sc_mcu7t5v0__mux2_1_2.Z VDDd.t142 pfet_05v0 ad=0.42982p pd=2.185u as=0.5368p ps=3.32u w=1.22u l=0.5u
X231 a_2079_679# lut_0.REG[3] VDDd.t167 VDDd.t166 pfet_05v0 ad=84.55f pd=0.89u as=0.42982p ps=2.185u w=0.615u l=0.5u
X232 VSSd.t61 a_210_n1839# a_490_n1661# VSSd.t60 nfet_05v0 ad=0.1209p pd=0.985u as=0.2046p ps=1.81u w=0.465u l=0.6u
X233 a_1310_n2460# a_570_n2459# a_1106_n2460# VDDd.t18 pfet_05v0 ad=0.372p pd=1.825u as=0.1638p ps=1.15u w=0.63u l=0.5u
X234 a_1350_n4532# a_122_n4531# a_1106_n4028# VSSd.t181 nfet_05v0 ad=0.15225p pd=1.165u as=0.1027p ps=0.915u w=0.395u l=0.6u
X235 a_598_939# lut_0.gf180mcu_fd_sc_mcu7t5v0__mux2_1_3.Z VDDd.t184 VDDd.t183 pfet_05v0 ad=73.8f pd=0.855u as=0.1599p ps=1.135u w=0.615u l=0.5u
X236 reg_bank_5bit_0.gf180mcu_fd_sc_mcu7t5v0__latq_1_8.D a_210_n3407# VSSd.t169 VSSd.t77 nfet_05v0 ad=0.3608p pd=2.52u as=0.3608p ps=2.52u w=0.82u l=0.6u
X237 VDDd.t152 a_1106_n5596# lut_0.REG[1] VDDd.t151 pfet_05v0 ad=0.5368p pd=3.32u as=0.5368p ps=3.32u w=1.22u l=0.5u
X238 VSSd.t118 a_2390_1770# a_2342_1814# VSSd.t117 nfet_05v0 ad=0.142p pd=1.14u as=43.2f ps=0.6u w=0.36u l=0.6u
X239 VDDd.t165 lut_0.REG[3] a_1406_n3766# VDDd.t164 pfet_05v0 ad=0.2772p pd=2.14u as=75.59999f ps=0.87u w=0.63u l=0.5u
X240 a_2052_1479# lut_0.LUT_OUT VSSd.t31 VSSd.t30 nfet_05v0 ad=43.2f pd=0.6u as=93.59999f ps=0.88u w=0.36u l=0.6u
X241 a_1106_n7164# a_122_n7667# a_958_n7164# VDDd.t38 pfet_05v0 ad=0.1638p pd=1.15u as=75.59999f ps=0.87u w=0.63u l=0.5u
X242 a_1106_n4028# a_122_n4531# a_958_n4028# VDDd.t174 pfet_05v0 ad=0.1638p pd=1.15u as=75.59999f ps=0.87u w=0.63u l=0.5u
X243 a_966_2182# a_534_2127# VDDd.t1 VDDd.t0 pfet_05v0 ad=54f pd=0.66u as=0.4554p ps=3.25u w=0.36u l=0.5u
R0 IN[0].n0 IN[0].t1 24.0436
R1 IN[0] IN[0].t0 19.3219
R2 IN[0].n2 IN[0].t2 17.0525
R3 IN[0].n0 IN[0].t3 9.0525
R4 IN[0].n1 IN[0].n0 8.0005
R5 IN[0].n4 IN[0] 1.64137
R6 IN[0].n4 IN[0].n3 1.5005
R7 IN[0].n2 IN[0].n1 0.373206
R8 IN[0] IN[0].n4 0.1805
R9 IN[0].n3 IN[0] 0.172029
R10 IN[0].n3 IN[0].n2 0.0492059
R11 IN[0].n1 IN[0] 0.0365
R12 VSSd.t58 VSSd 2765.6
R13 VSSd.t87 VSSd.t85 2730.59
R14 VSSd.t34 VSSd.t194 2730.59
R15 VSSd.t138 VSSd 2033.1
R16 VSSd.t33 VSSd.t145 1929.22
R17 VSSd.t153 VSSd.t34 1929.22
R18 VSSd.t145 VSSd.t87 1662.1
R19 VSSd.t21 VSSd.t33 1662.1
R20 VSSd VSSd.t159 1556.46
R21 VSSd.n15 VSSd 1528.76
R22 VSSd.t85 VSSd 1439.5
R23 VSSd VSSd.t58 1291.1
R24 VSSd VSSd.t138 1291.1
R25 VSSd VSSd.t153 1291.1
R26 VSSd.t89 VSSd 1264.91
R27 VSSd.t36 VSSd 1264.91
R28 VSSd.t194 VSSd.t21 1246.58
R29 VSSd.t54 VSSd.t125 1200.28
R30 VSSd.t47 VSSd.t12 1200.28
R31 VSSd.t62 VSSd.t91 1200.28
R32 VSSd.t7 VSSd.t107 1200.28
R33 VSSd.t77 VSSd.t17 1200.28
R34 VSSd.t114 VSSd.t99 1200.28
R35 VSSd.t148 VSSd.t182 1200.28
R36 VSSd.t94 VSSd.t81 1200.28
R37 VSSd.t67 VSSd.t71 1200.28
R38 VSSd.t142 VSSd.t1 1181.82
R39 VSSd.t2 VSSd.t136 1135.65
R40 VSSd.t42 VSSd.t159 1034.09
R41 VSSd.t24 VSSd.t44 1034.09
R42 VSSd.t60 VSSd.t79 1034.09
R43 VSSd.t167 VSSd.t109 1034.09
R44 VSSd.t170 VSSd.t14 1034.09
R45 VSSd.t52 VSSd.t97 1034.09
R46 VSSd.t197 VSSd.t127 1034.09
R47 VSSd.t103 VSSd.t162 1034.09
R48 VSSd.t185 VSSd.t38 1034.09
R49 VSSd VSSd.t119 1015.62
R50 VSSd VSSd.n49 1006.39
R51 VSSd VSSd.n71 1006.39
R52 VSSd.t6 VSSd.t133 886.365
R53 VSSd.t74 VSSd.t172 830.966
R54 VSSd VSSd.t28 803.268
R55 VSSd VSSd.t187 803.268
R56 VSSd VSSd.t54 803.268
R57 VSSd VSSd.t62 803.268
R58 VSSd VSSd.t77 803.268
R59 VSSd VSSd.t26 803.268
R60 VSSd VSSd.t148 803.268
R61 VSSd VSSd.t121 803.268
R62 VSSd VSSd.t67 803.268
R63 VSSd.t189 VSSd.t23 775.568
R64 VSSd.t135 VSSd.t131 775.568
R65 VSSd.t102 VSSd.t155 775.568
R66 VSSd.t113 VSSd.t40 775.568
R67 VSSd.t49 VSSd.t93 775.568
R68 VSSd.t50 VSSd.t111 775.568
R69 VSSd.t144 VSSd.t174 775.568
R70 VSSd.t9 VSSd.t16 775.568
R71 VSSd.t83 VSSd.t64 775.568
R72 VSSd.t22 VSSd.t157 775.568
R73 VSSd.t116 VSSd.t181 775.568
R74 VSSd.t165 VSSd.t147 775.568
R75 VSSd.t178 VSSd.t123 775.568
R76 VSSd.t96 VSSd.t73 775.568
R77 VSSd.t191 VSSd.t161 775.568
R78 VSSd.t201 VSSd.t10 766.336
R79 VSSd.t101 VSSd.t129 757.102
R80 VSSd VSSd.t70 747.87
R81 VSSd.t65 VSSd.t30 729.404
R82 VSSd.t23 VSSd.t151 720.17
R83 VSSd.t176 VSSd.t105 720.17
R84 VSSd.t187 VSSd.t4 720.17
R85 VSSd.t200 VSSd.t193 563.211
R86 VSSd.n16 VSSd 544.745
R87 VSSd.n40 VSSd 544.745
R88 VSSd.n62 VSSd 544.745
R89 VSSd.n84 VSSd 544.745
R90 VSSd.n106 VSSd 544.745
R91 VSSd.n128 VSSd 544.745
R92 VSSd.t125 VSSd.t56 498.58
R93 VSSd.t44 VSSd.t47 498.58
R94 VSSd.t91 VSSd.t60 498.58
R95 VSSd.t109 VSSd.t7 498.58
R96 VSSd.t17 VSSd.t170 498.58
R97 VSSd.t97 VSSd.t114 498.58
R98 VSSd.t182 VSSd.t197 498.58
R99 VSSd.t162 VSSd.t94 498.58
R100 VSSd.t71 VSSd.t185 498.58
R101 VSSd VSSd.n105 489.348
R102 VSSd VSSd.n127 489.348
R103 VSSd.n39 VSSd.t42 480.115
R104 VSSd.t4 VSSd.t176 480.115
R105 VSSd.t117 VSSd.t201 470.882
R106 VSSd.t193 VSSd.t140 470.882
R107 VSSd.t0 VSSd.t200 470.882
R108 VSSd.t76 VSSd.t32 461.649
R109 VSSd.t10 VSSd.t19 433.95
R110 VSSd VSSd.t2 415.483
R111 VSSd.t19 VSSd 341.62
R112 VSSd.t179 VSSd 341.62
R113 VSSd.t12 VSSd 341.62
R114 VSSd.t107 VSSd 341.62
R115 VSSd.t99 VSSd 341.62
R116 VSSd.t81 VSSd 341.62
R117 VSSd.t32 VSSd.t142 313.921
R118 VSSd.t151 VSSd.t76 313.921
R119 VSSd.n105 VSSd.t89 313.921
R120 VSSd.n127 VSSd.t36 313.921
R121 VSSd.t140 VSSd.t117 304.688
R122 VSSd.t30 VSSd.t0 304.688
R123 VSSd.t136 VSSd.t65 304.688
R124 VSSd.t70 VSSd.n39 295.455
R125 VSSd.t141 VSSd 286.223
R126 VSSd.t129 VSSd.t102 276.99
R127 VSSd.t56 VSSd.t101 276.99
R128 VSSd.t93 VSSd.t113 258.524
R129 VSSd.t111 VSSd.t49 258.524
R130 VSSd.t16 VSSd.t144 258.524
R131 VSSd.t64 VSSd.t9 258.524
R132 VSSd.t181 VSSd.t22 258.524
R133 VSSd.t147 VSSd.t116 258.524
R134 VSSd.t73 VSSd.t178 258.524
R135 VSSd.t161 VSSd.t96 258.524
R136 VSSd.t172 VSSd.t189 203.125
R137 VSSd.t28 VSSd.t74 203.125
R138 VSSd.t131 VSSd 175.427
R139 VSSd.t40 VSSd.t24 166.194
R140 VSSd.t79 VSSd.t50 166.194
R141 VSSd.t174 VSSd.t167 166.194
R142 VSSd.t14 VSSd.t83 166.194
R143 VSSd.t157 VSSd.t52 166.194
R144 VSSd.t127 VSSd.t165 166.194
R145 VSSd.t123 VSSd.t103 166.194
R146 VSSd.t38 VSSd.t191 166.194
R147 VSSd.t133 VSSd.t135 147.727
R148 VSSd.t155 VSSd.t6 147.727
R149 VSSd.t105 VSSd.t141 55.3982
R150 VSSd VSSd.n16 42.2541
R151 VSSd VSSd.n40 42.2541
R152 VSSd VSSd.n62 42.2541
R153 VSSd VSSd.n84 42.2541
R154 VSSd VSSd.n106 42.2541
R155 VSSd VSSd.n128 42.2541
R156 VSSd.n49 VSSd.n48 42.1323
R157 VSSd.n71 VSSd.n70 42.1323
R158 VSSd.t119 VSSd.n15 27.6994
R159 VSSd.t1 VSSd.t179 18.4664
R160 VSSd.n20 VSSd.n7 11.988
R161 VSSd.n10 VSSd.t152 10.8505
R162 VSSd.n31 VSSd.t132 10.4473
R163 VSSd.n56 VSSd.t51 10.4473
R164 VSSd.n55 VSSd.t41 10.4473
R165 VSSd.n78 VSSd.t84 10.4473
R166 VSSd.n77 VSSd.t175 10.4473
R167 VSSd.n99 VSSd.t166 10.4473
R168 VSSd.n98 VSSd.t158 10.4473
R169 VSSd.n121 VSSd.t192 10.4473
R170 VSSd.n120 VSSd.t124 10.4473
R171 VSSd.n140 VSSd.t195 10.4473
R172 VSSd VSSd.t27 8.51132
R173 VSSd VSSd.t90 8.51132
R174 VSSd VSSd.t122 8.51132
R175 VSSd VSSd.t37 8.51132
R176 VSSd VSSd.t59 8.51132
R177 VSSd VSSd.t139 8.51132
R178 VSSd.n7 VSSd.t66 8.4005
R179 VSSd.n7 VSSd.t3 8.4005
R180 VSSd VSSd.t120 8.35089
R181 VSSd.n37 VSSd.t55 8.29806
R182 VSSd.n50 VSSd.t46 8.29806
R183 VSSd.n60 VSSd.t63 8.29806
R184 VSSd.n72 VSSd.t108 8.29806
R185 VSSd.n82 VSSd.t169 8.29806
R186 VSSd.n93 VSSd.t100 8.29806
R187 VSSd.n103 VSSd.t199 8.29806
R188 VSSd.n115 VSSd.t164 8.29806
R189 VSSd.n125 VSSd.t184 8.29806
R190 VSSd.n137 VSSd.t86 8.29806
R191 VSSd.n3 VSSd.t118 8.0855
R192 VSSd.n28 VSSd.t5 6.76405
R193 VSSd.n59 VSSd.t92 6.76405
R194 VSSd.n51 VSSd.t48 6.76405
R195 VSSd.n81 VSSd.t18 6.76405
R196 VSSd.n73 VSSd.t8 6.76405
R197 VSSd.n102 VSSd.t183 6.76405
R198 VSSd.n94 VSSd.t115 6.76405
R199 VSSd.n124 VSSd.t72 6.76405
R200 VSSd.n116 VSSd.t95 6.76405
R201 VSSd.n141 VSSd.t35 6.76405
R202 VSSd VSSd.n30 6.45507
R203 VSSd VSSd.n36 6.45507
R204 VSSd VSSd.n59 6.4355
R205 VSSd VSSd.n81 6.4355
R206 VSSd VSSd.n102 6.4355
R207 VSSd VSSd.n124 6.4355
R208 VSSd VSSd.n141 6.4355
R209 VSSd.n8 VSSd.t143 6.32611
R210 VSSd.n1 VSSd.t202 6.32611
R211 VSSd.n30 VSSd.t177 6.32611
R212 VSSd.n36 VSSd.t126 6.32611
R213 VSSd VSSd.n13 6.31241
R214 VSSd.n4 VSSd.n3 6.3005
R215 VSSd.n12 VSSd.n11 6.3005
R216 VSSd.n9 VSSd.n8 6.3005
R217 VSSd.n6 VSSd.n5 6.3005
R218 VSSd.n2 VSSd.n1 6.3005
R219 VSSd.n26 VSSd.n25 6.3005
R220 VSSd.n33 VSSd.n32 6.3005
R221 VSSd.n35 VSSd.n34 6.3005
R222 VSSd.n29 VSSd.n28 6.3005
R223 VSSd.n54 VSSd.n53 6.3005
R224 VSSd.n58 VSSd.n57 6.3005
R225 VSSd.n52 VSSd.n51 6.3005
R226 VSSd.n76 VSSd.n75 6.3005
R227 VSSd.n80 VSSd.n79 6.3005
R228 VSSd.n74 VSSd.n73 6.3005
R229 VSSd.n97 VSSd.n96 6.3005
R230 VSSd.n101 VSSd.n100 6.3005
R231 VSSd.n95 VSSd.n94 6.3005
R232 VSSd.n119 VSSd.n118 6.3005
R233 VSSd.n123 VSSd.n122 6.3005
R234 VSSd.n117 VSSd.n116 6.3005
R235 VSSd.n139 VSSd.n138 6.3005
R236 VSSd.n47 VSSd.n24 5.62946
R237 VSSd VSSd.n49 5.32226
R238 VSSd VSSd.n71 5.32226
R239 VSSd.n91 VSSd.n90 5.20625
R240 VSSd.n69 VSSd.n68 5.2055
R241 VSSd.n16 VSSd.n14 5.2005
R242 VSSd.n15 VSSd.n0 5.2005
R243 VSSd.n40 VSSd.n38 5.2005
R244 VSSd.n39 VSSd.n27 5.2005
R245 VSSd.n62 VSSd.n61 5.2005
R246 VSSd.n84 VSSd.n83 5.2005
R247 VSSd.n106 VSSd.n104 5.2005
R248 VSSd.n105 VSSd.n92 5.2005
R249 VSSd.n128 VSSd.n126 5.2005
R250 VSSd.n127 VSSd.n114 5.2005
R251 VSSd.n135 VSSd 4.90475
R252 VSSd.n113 VSSd 4.9025
R253 VSSd.n47 VSSd 4.70975
R254 VSSd.n11 VSSd.t190 4.5505
R255 VSSd.n11 VSSd.t75 4.5505
R256 VSSd.n5 VSSd.t31 4.5505
R257 VSSd.n5 VSSd.t137 4.5505
R258 VSSd.n25 VSSd.t160 4.5505
R259 VSSd.n25 VSSd.t43 4.5505
R260 VSSd.n32 VSSd.t134 4.5505
R261 VSSd.n32 VSSd.t156 4.5505
R262 VSSd VSSd.n136 4.54175
R263 VSSd.n3 VSSd.t11 4.0955
R264 VSSd.n13 VSSd.t173 4.04494
R265 VSSd.n13 VSSd.t29 4.04494
R266 VSSd.n28 VSSd.t106 3.56137
R267 VSSd.n59 VSSd.t69 3.56137
R268 VSSd.n51 VSSd.t13 3.56137
R269 VSSd.n81 VSSd.t78 3.56137
R270 VSSd.n73 VSSd.t112 3.56137
R271 VSSd.n102 VSSd.t149 3.56137
R272 VSSd.n94 VSSd.t196 3.56137
R273 VSSd.n124 VSSd.t68 3.56137
R274 VSSd.n116 VSSd.t82 3.56137
R275 VSSd.n141 VSSd.t154 3.56137
R276 VSSd.n34 VSSd.t130 3.52308
R277 VSSd.n34 VSSd.t57 3.52308
R278 VSSd.n53 VSSd.t45 3.52308
R279 VSSd.n53 VSSd.t25 3.52308
R280 VSSd.n57 VSSd.t80 3.52308
R281 VSSd.n57 VSSd.t61 3.52308
R282 VSSd.n75 VSSd.t110 3.52308
R283 VSSd.n75 VSSd.t168 3.52308
R284 VSSd.n79 VSSd.t15 3.52308
R285 VSSd.n79 VSSd.t171 3.52308
R286 VSSd.n96 VSSd.t98 3.52308
R287 VSSd.n96 VSSd.t53 3.52308
R288 VSSd.n100 VSSd.t128 3.52308
R289 VSSd.n100 VSSd.t198 3.52308
R290 VSSd.n118 VSSd.t163 3.52308
R291 VSSd.n118 VSSd.t104 3.52308
R292 VSSd.n122 VSSd.t39 3.52308
R293 VSSd.n122 VSSd.t186 3.52308
R294 VSSd.n138 VSSd.t88 3.52308
R295 VSSd.n138 VSSd.t146 3.52308
R296 VSSd.n8 VSSd.t180 1.99806
R297 VSSd.n1 VSSd.t20 1.99806
R298 VSSd.n30 VSSd.t188 1.99806
R299 VSSd.n36 VSSd.t150 1.99806
R300 VSSd.n136 VSSd.n135 1.1309
R301 VSSd.n69 VSSd.n47 1.13018
R302 VSSd.n91 VSSd.n69 1.13018
R303 VSSd.n113 VSSd.n91 1.13018
R304 VSSd.n135 VSSd.n113 1.12874
R305 VSSd.n66 VSSd 0.6305
R306 VSSd.n88 VSSd 0.6305
R307 VSSd.n110 VSSd 0.6305
R308 VSSd.n132 VSSd 0.6305
R309 VSSd VSSd.n21 0.545
R310 VSSd.n19 VSSd 0.3725
R311 VSSd VSSd.n43 0.3395
R312 VSSd.n43 VSSd 0.2765
R313 VSSd.n67 VSSd 0.2765
R314 VSSd.n65 VSSd 0.2765
R315 VSSd.n89 VSSd 0.2765
R316 VSSd.n87 VSSd 0.2765
R317 VSSd.n111 VSSd 0.2765
R318 VSSd.n109 VSSd 0.2765
R319 VSSd.n133 VSSd 0.2765
R320 VSSd.n131 VSSd 0.2765
R321 VSSd VSSd.n112 0.2495
R322 VSSd VSSd.n134 0.2495
R323 VSSd VSSd.n18 0.2435
R324 VSSd VSSd.n45 0.2225
R325 VSSd VSSd.n22 0.221
R326 VSSd VSSd.n19 0.221
R327 VSSd.n42 VSSd 0.202022
R328 VSSd.n64 VSSd 0.202022
R329 VSSd.n86 VSSd 0.202022
R330 VSSd.n108 VSSd 0.202022
R331 VSSd.n130 VSSd 0.202022
R332 VSSd VSSd.n42 0.1685
R333 VSSd VSSd.n67 0.1685
R334 VSSd VSSd.n64 0.1685
R335 VSSd VSSd.n89 0.1685
R336 VSSd VSSd.n86 0.1685
R337 VSSd VSSd.n111 0.1685
R338 VSSd VSSd.n108 0.1685
R339 VSSd VSSd.n133 0.1685
R340 VSSd VSSd.n130 0.1685
R341 VSSd VSSd.n23 0.167
R342 VSSd VSSd.n46 0.1625
R343 VSSd VSSd.n44 0.1595
R344 VSSd.n18 VSSd.n12 0.157022
R345 VSSd.n21 VSSd.n6 0.157022
R346 VSSd VSSd.n26 0.157022
R347 VSSd VSSd.n33 0.157022
R348 VSSd.n19 VSSd.n9 0.155065
R349 VSSd.n22 VSSd.n2 0.155065
R350 VSSd.n21 VSSd.n20 0.152
R351 VSSd.n45 VSSd 0.1445
R352 VSSd.n43 VSSd.n35 0.1355
R353 VSSd.n44 VSSd.n31 0.1355
R354 VSSd.n45 VSSd.n29 0.1355
R355 VSSd VSSd.n54 0.1355
R356 VSSd VSSd.n56 0.1355
R357 VSSd.n65 VSSd.n58 0.1355
R358 VSSd.n66 VSSd.n55 0.1355
R359 VSSd.n67 VSSd.n52 0.1355
R360 VSSd VSSd.n76 0.1355
R361 VSSd VSSd.n78 0.1355
R362 VSSd.n87 VSSd.n80 0.1355
R363 VSSd.n88 VSSd.n77 0.1355
R364 VSSd.n89 VSSd.n74 0.1355
R365 VSSd VSSd.n97 0.1355
R366 VSSd VSSd.n99 0.1355
R367 VSSd.n109 VSSd.n101 0.1355
R368 VSSd.n110 VSSd.n98 0.1355
R369 VSSd.n111 VSSd.n95 0.1355
R370 VSSd VSSd.n119 0.1355
R371 VSSd VSSd.n121 0.1355
R372 VSSd.n131 VSSd.n123 0.1355
R373 VSSd.n132 VSSd.n120 0.1355
R374 VSSd.n133 VSSd.n117 0.1355
R375 VSSd VSSd.n139 0.1355
R376 VSSd VSSd.n140 0.1355
R377 VSSd.n17 VSSd.n14 0.123588
R378 VSSd.n23 VSSd.n0 0.123588
R379 VSSd.n41 VSSd.n38 0.123588
R380 VSSd.n46 VSSd.n27 0.123588
R381 VSSd.n63 VSSd.n61 0.123588
R382 VSSd.n68 VSSd.n48 0.123588
R383 VSSd.n85 VSSd.n83 0.123588
R384 VSSd.n90 VSSd.n70 0.123588
R385 VSSd.n107 VSSd.n104 0.123588
R386 VSSd.n112 VSSd.n92 0.123588
R387 VSSd.n129 VSSd.n126 0.123588
R388 VSSd.n134 VSSd.n114 0.123588
R389 VSSd.n14 VSSd 0.113
R390 VSSd.n0 VSSd 0.113
R391 VSSd.n38 VSSd 0.113
R392 VSSd.n27 VSSd 0.113
R393 VSSd.n61 VSSd 0.113
R394 VSSd.n48 VSSd 0.113
R395 VSSd.n83 VSSd 0.113
R396 VSSd.n70 VSSd 0.113
R397 VSSd.n104 VSSd 0.113
R398 VSSd.n92 VSSd 0.113
R399 VSSd.n126 VSSd 0.113
R400 VSSd.n114 VSSd 0.113
R401 VSSd.n20 VSSd 0.104
R402 VSSd.n23 VSSd 0.0875
R403 VSSd.n46 VSSd 0.0875
R404 VSSd VSSd.n17 0.0815
R405 VSSd VSSd.n63 0.0815
R406 VSSd VSSd.n85 0.0815
R407 VSSd VSSd.n107 0.0815
R408 VSSd VSSd.n129 0.0815
R409 VSSd VSSd.n41 0.08075
R410 VSSd.n22 VSSd 0.071
R411 VSSd.n9 VSSd 0.0670217
R412 VSSd.n2 VSSd 0.0670217
R413 VSSd.n35 VSSd 0.0670217
R414 VSSd.n31 VSSd 0.0670217
R415 VSSd.n29 VSSd 0.0670217
R416 VSSd.n54 VSSd 0.0670217
R417 VSSd.n56 VSSd 0.0670217
R418 VSSd.n58 VSSd 0.0670217
R419 VSSd.n55 VSSd 0.0670217
R420 VSSd.n52 VSSd 0.0670217
R421 VSSd.n76 VSSd 0.0670217
R422 VSSd.n78 VSSd 0.0670217
R423 VSSd.n80 VSSd 0.0670217
R424 VSSd.n77 VSSd 0.0670217
R425 VSSd.n74 VSSd 0.0670217
R426 VSSd.n97 VSSd 0.0670217
R427 VSSd.n99 VSSd 0.0670217
R428 VSSd.n101 VSSd 0.0670217
R429 VSSd.n98 VSSd 0.0670217
R430 VSSd.n95 VSSd 0.0670217
R431 VSSd.n119 VSSd 0.0670217
R432 VSSd.n121 VSSd 0.0670217
R433 VSSd.n123 VSSd 0.0670217
R434 VSSd.n120 VSSd 0.0670217
R435 VSSd.n117 VSSd 0.0670217
R436 VSSd.n139 VSSd 0.0670217
R437 VSSd.n140 VSSd 0.0670217
R438 VSSd.n12 VSSd 0.0650652
R439 VSSd.n6 VSSd 0.0650652
R440 VSSd.n26 VSSd 0.0650652
R441 VSSd.n33 VSSd 0.0650652
R442 VSSd.n44 VSSd 0.0635
R443 VSSd.n42 VSSd 0.0545
R444 VSSd.n64 VSSd 0.0545
R445 VSSd.n86 VSSd 0.0545
R446 VSSd.n108 VSSd 0.0545
R447 VSSd.n130 VSSd 0.0545
R448 VSSd.n20 VSSd 0.0541842
R449 VSSd.n4 VSSd 0.0455
R450 VSSd.n24 VSSd 0.04325
R451 VSSd.n136 VSSd 0.04154
R452 VSSd.n24 VSSd 0.03875
R453 VSSd.n18 VSSd 0.0335
R454 VSSd.n112 VSSd 0.0335
R455 VSSd.n134 VSSd 0.0335
R456 VSSd VSSd.n66 0.0275
R457 VSSd VSSd.n65 0.0275
R458 VSSd VSSd.n88 0.0275
R459 VSSd VSSd.n87 0.0275
R460 VSSd VSSd.n110 0.0275
R461 VSSd VSSd.n109 0.0275
R462 VSSd VSSd.n132 0.0275
R463 VSSd VSSd.n131 0.0275
R464 VSSd VSSd.n10 0.023
R465 VSSd.n10 VSSd 0.0203529
R466 VSSd.n37 VSSd 0.0200652
R467 VSSd.n50 VSSd 0.0200652
R468 VSSd.n60 VSSd 0.0200652
R469 VSSd.n72 VSSd 0.0200652
R470 VSSd.n82 VSSd 0.0200652
R471 VSSd.n93 VSSd 0.0200652
R472 VSSd.n103 VSSd 0.0200652
R473 VSSd.n115 VSSd 0.0200652
R474 VSSd.n125 VSSd 0.0200652
R475 VSSd.n137 VSSd 0.0200652
R476 VSSd VSSd.n4 0.0181087
R477 VSSd VSSd.n37 0.00832609
R478 VSSd VSSd.n50 0.00832609
R479 VSSd VSSd.n60 0.00832609
R480 VSSd VSSd.n72 0.00832609
R481 VSSd VSSd.n82 0.00832609
R482 VSSd VSSd.n93 0.00832609
R483 VSSd VSSd.n103 0.00832609
R484 VSSd VSSd.n115 0.00832609
R485 VSSd VSSd.n125 0.00832609
R486 VSSd VSSd.n137 0.00832609
R487 VSSd.n17 VSSd 0.0065
R488 VSSd.n41 VSSd 0.0065
R489 VSSd.n68 VSSd 0.0065
R490 VSSd.n63 VSSd 0.0065
R491 VSSd.n90 VSSd 0.0065
R492 VSSd.n85 VSSd 0.0065
R493 VSSd.n107 VSSd 0.0065
R494 VSSd.n129 VSSd 0.0065
R495 VDDd.t0 VDDd.t101 833.977
R496 VDDd.n20 VDDd.t116 691.12
R497 VDDd.t116 VDDd.t12 671.816
R498 VDDd.t86 VDDd.t71 577.221
R499 VDDd.t2 VDDd.t86 550.193
R500 VDDd.t12 VDDd.t114 478.764
R501 VDDd.n239 VDDd.t61 418.981
R502 VDDd.t71 VDDd.t3 416.988
R503 VDDd.t101 VDDd.t109 393.822
R504 VDDd.t109 VDDd 355.212
R505 VDDd.t63 VDDd 305.557
R506 VDDd.t144 VDDd 305.557
R507 VDDd VDDd.t132 305.557
R508 VDDd.t114 VDDd.t2 301.159
R509 VDDd.t3 VDDd.t168 285.714
R510 VDDd.t97 VDDd.t8 277.779
R511 VDDd.t175 VDDd.t158 277.779
R512 VDDd.t151 VDDd.t111 277.779
R513 VDDd.t75 VDDd.t189 277.779
R514 VDDd.t82 VDDd.t95 277.779
R515 VDDd.t39 VDDd.t177 277.779
R516 VDDd.n19 VDDd.t0 276.062
R517 VDDd.t99 VDDd.t55 259.26
R518 VDDd.t14 VDDd.t160 259.26
R519 VDDd.t153 VDDd.t104 259.26
R520 VDDd.t124 VDDd.t191 259.26
R521 VDDd.t84 VDDd.t139 259.26
R522 VDDd.t42 VDDd.t179 259.26
R523 VDDd.n57 VDDd 254.335
R524 VDDd VDDd.n18 243.244
R525 VDDd.t10 VDDd.t46 235.839
R526 VDDd.t36 VDDd.t130 235.839
R527 VDDd.t32 VDDd.t148 235.839
R528 VDDd.t183 VDDd.t77 235.839
R529 VDDd VDDd.t30 212.964
R530 VDDd VDDd.t118 212.964
R531 VDDd.t61 VDDd 212.964
R532 VDDd.t181 VDDd 212.718
R533 VDDd.t142 VDDd 212.718
R534 VDDd.t25 VDDd.t103 198.845
R535 VDDd.t193 VDDd.t73 196.532
R536 VDDd.t16 VDDd 189.815
R537 VDDd.t87 VDDd 189.815
R538 VDDd.t170 VDDd 189.815
R539 VDDd.t164 VDDd.t7 171.297
R540 VDDd.t174 VDDd.t155 171.297
R541 VDDd.t146 VDDd.t113 171.297
R542 VDDd.t74 VDDd.t185 171.297
R543 VDDd.t120 VDDd.t94 171.297
R544 VDDd.t38 VDDd.t187 171.297
R545 VDDd.t8 VDDd.t99 148.149
R546 VDDd.t160 VDDd.t175 148.149
R547 VDDd.t111 VDDd.t153 148.149
R548 VDDd.t191 VDDd.t75 148.149
R549 VDDd.t95 VDDd.t84 148.149
R550 VDDd.t179 VDDd.t39 148.149
R551 VDDd.t168 VDDd.n19 142.857
R552 VDDd.t134 VDDd.t89 142.197
R553 VDDd.t79 VDDd.t122 142.197
R554 VDDd.t194 VDDd.t34 139.885
R555 VDDd.t129 VDDd.t166 139.885
R556 VDDd VDDd.n160 136.575
R557 VDDd VDDd.n190 136.575
R558 VDDd VDDd.n220 136.575
R559 VDDd VDDd.n36 136.417
R560 VDDd.t141 VDDd.t136 125.001
R561 VDDd.t150 VDDd.t24 125.001
R562 VDDd.t23 VDDd.t169 125.001
R563 VDDd.n173 VDDd 122.686
R564 VDDd.n203 VDDd 122.686
R565 VDDd.n233 VDDd 122.686
R566 VDDd.t7 VDDd.t141 111.112
R567 VDDd.t136 VDDd.t174 111.112
R568 VDDd.t113 VDDd.t150 111.112
R569 VDDd.t24 VDDd.t74 111.112
R570 VDDd.t94 VDDd.t23 111.112
R571 VDDd.t169 VDDd.t38 111.112
R572 VDDd VDDd.t21 97.1103
R573 VDDd VDDd.t172 97.1103
R574 VDDd.n173 VDDd.t63 90.2783
R575 VDDd.n203 VDDd.t144 90.2783
R576 VDDd.t132 VDDd.n233 90.2783
R577 VDDd VDDd.t92 74.0746
R578 VDDd VDDd.t127 74.0746
R579 VDDd VDDd.t137 74.0746
R580 VDDd.t172 VDDd.t32 73.9889
R581 VDDd.t77 VDDd.t142 73.9889
R582 VDDd.t21 VDDd.t10 71.6768
R583 VDDd.t130 VDDd.t181 71.6768
R584 VDDd.t55 VDDd.t164 41.6672
R585 VDDd.t155 VDDd.t14 41.6672
R586 VDDd.t104 VDDd.t146 41.6672
R587 VDDd.t185 VDDd.t124 41.6672
R588 VDDd.t139 VDDd.t120 41.6672
R589 VDDd.t187 VDDd.t42 41.6672
R590 VDDd.n99 VDDd 40.8485
R591 VDDd.n143 VDDd 40.8485
R592 VDDd.t34 VDDd.t193 39.3069
R593 VDDd.t73 VDDd.t129 39.3069
R594 VDDd.t89 VDDd.t25 36.9947
R595 VDDd.t103 VDDd.t79 36.9947
R596 VDDd.n83 VDDd.n82 33.0925
R597 VDDd.n95 VDDd.n94 33.0925
R598 VDDd.n127 VDDd.n126 33.0925
R599 VDDd.n139 VDDd.n138 33.0925
R600 VDDd.t46 VDDd.t194 31.2144
R601 VDDd.t166 VDDd.t36 31.2144
R602 VDDd.t148 VDDd.t134 28.9022
R603 VDDd.t122 VDDd.t183 28.9022
R604 VDDd.n19 VDDd.t35 28.8573
R605 VDDd.t92 VDDd.t97 23.1486
R606 VDDd.t158 VDDd.t16 23.1486
R607 VDDd.t127 VDDd.t151 23.1486
R608 VDDd.t189 VDDd.t87 23.1486
R609 VDDd.t137 VDDd.t82 23.1486
R610 VDDd.t177 VDDd.t170 23.1486
R611 VDDd.n3 VDDd.t1 21.5338
R612 VDDd VDDd.n98 14.9953
R613 VDDd VDDd.n142 14.9953
R614 VDDd.n83 VDDd.t57 11.893
R615 VDDd.n95 VDDd.t49 11.893
R616 VDDd.n127 VDDd.t67 11.893
R617 VDDd.n139 VDDd.t107 11.893
R618 VDDd VDDd.n57 11.2957
R619 VDDd.n17 VDDd.n14 11.2005
R620 VDDd.n21 VDDd.n10 11.2005
R621 VDDd.n33 VDDd.n30 11.2005
R622 VDDd.n56 VDDd.n55 11.2005
R623 VDDd.n85 VDDd.n84 11.2005
R624 VDDd.n100 VDDd.n80 11.2005
R625 VDDd.n90 VDDd.n86 11.2005
R626 VDDd.n93 VDDd.n90 11.2005
R627 VDDd.n97 VDDd.n96 11.2005
R628 VDDd.n96 VDDd.n87 11.2005
R629 VDDd.n129 VDDd.n128 11.2005
R630 VDDd.n144 VDDd.n124 11.2005
R631 VDDd.n134 VDDd.n130 11.2005
R632 VDDd.n137 VDDd.n134 11.2005
R633 VDDd.n141 VDDd.n140 11.2005
R634 VDDd.n140 VDDd.n131 11.2005
R635 VDDd.n158 VDDd.n157 11.2005
R636 VDDd.n188 VDDd.n187 11.2005
R637 VDDd.n217 VDDd.n214 11.2005
R638 VDDd.n240 VDDd.n236 11.2005
R639 VDDd.n82 VDDd.n81 9.32391
R640 VDDd.n82 VDDd.n79 9.32391
R641 VDDd.n126 VDDd.n125 9.32391
R642 VDDd.n126 VDDd.n123 9.32391
R643 VDDd.n13 VDDd.n0 9.26571
R644 VDDd.n12 VDDd.n11 9.26571
R645 VDDd.n34 VDDd.n29 9.26571
R646 VDDd.n53 VDDd.n52 9.26571
R647 VDDd.n155 VDDd.n154 9.26571
R648 VDDd.n185 VDDd.n184 9.26571
R649 VDDd.n218 VDDd.n213 9.26571
R650 VDDd.n238 VDDd.n237 9.26571
R651 VDDd.n160 VDDd.n159 9.25976
R652 VDDd.n190 VDDd.n189 9.25976
R653 VDDd.n220 VDDd.n219 9.25976
R654 VDDd.n36 VDDd.n35 9.24905
R655 VDDd VDDd.t41 8.23222
R656 VDDd VDDd.t45 8.23222
R657 VDDd VDDd.t165 8.23222
R658 VDDd VDDd.t147 8.23222
R659 VDDd VDDd.t121 8.23222
R660 VDDd.n72 VDDd.t54 8.08939
R661 VDDd.n116 VDDd.t81 8.08939
R662 VDDd.n166 VDDd.t156 8.08939
R663 VDDd.n196 VDDd.t186 8.08939
R664 VDDd.n226 VDDd.t188 8.08939
R665 VDDd.n49 VDDd.t195 8.02489
R666 VDDd.n42 VDDd.t135 8.02489
R667 VDDd.n37 VDDd.t123 8.02489
R668 VDDd.n44 VDDd.t167 8.02489
R669 VDDd.t49 VDDd.t28 7.75645
R670 VDDd.t107 VDDd.t26 7.75645
R671 VDDd.t57 VDDd.t59 7.49791
R672 VDDd.t162 VDDd.t5 7.49791
R673 VDDd.t28 VDDd.t53 7.49791
R674 VDDd.t67 VDDd.t69 7.49791
R675 VDDd.t65 VDDd.t44 7.49791
R676 VDDd.t26 VDDd.t18 7.49791
R677 VDDd.n6 VDDd.t115 7.40883
R678 VDDd.n15 VDDd.n14 6.3005
R679 VDDd.n17 VDDd.n16 6.3005
R680 VDDd.n18 VDDd.n17 6.3005
R681 VDDd.n22 VDDd.n21 6.3005
R682 VDDd.n21 VDDd.n20 6.3005
R683 VDDd.n10 VDDd.n9 6.3005
R684 VDDd.n33 VDDd.n32 6.3005
R685 VDDd.n31 VDDd.n30 6.3005
R686 VDDd.n35 VDDd.n30 6.3005
R687 VDDd.n56 VDDd.n51 6.3005
R688 VDDd.n57 VDDd.n56 6.3005
R689 VDDd.n55 VDDd.n54 6.3005
R690 VDDd.n86 VDDd.n65 6.3005
R691 VDDd.n98 VDDd.n86 6.3005
R692 VDDd.n91 VDDd.n90 6.3005
R693 VDDd.n95 VDDd.n90 6.3005
R694 VDDd.n93 VDDd.n92 6.3005
R695 VDDd.n94 VDDd.n93 6.3005
R696 VDDd.n83 VDDd.n80 6.3005
R697 VDDd.n101 VDDd.n100 6.3005
R698 VDDd.n100 VDDd.n99 6.3005
R699 VDDd.n84 VDDd.n83 6.3005
R700 VDDd.n85 VDDd.n66 6.3005
R701 VDDd.n99 VDDd.n85 6.3005
R702 VDDd.n97 VDDd.n78 6.3005
R703 VDDd.n98 VDDd.n97 6.3005
R704 VDDd.n96 VDDd.n89 6.3005
R705 VDDd.n96 VDDd.n95 6.3005
R706 VDDd.n88 VDDd.n87 6.3005
R707 VDDd.n94 VDDd.n87 6.3005
R708 VDDd.n130 VDDd.n109 6.3005
R709 VDDd.n142 VDDd.n130 6.3005
R710 VDDd.n135 VDDd.n134 6.3005
R711 VDDd.n139 VDDd.n134 6.3005
R712 VDDd.n137 VDDd.n136 6.3005
R713 VDDd.n138 VDDd.n137 6.3005
R714 VDDd.n127 VDDd.n124 6.3005
R715 VDDd.n145 VDDd.n144 6.3005
R716 VDDd.n144 VDDd.n143 6.3005
R717 VDDd.n128 VDDd.n127 6.3005
R718 VDDd.n129 VDDd.n110 6.3005
R719 VDDd.n143 VDDd.n129 6.3005
R720 VDDd.n141 VDDd.n122 6.3005
R721 VDDd.n142 VDDd.n141 6.3005
R722 VDDd.n140 VDDd.n133 6.3005
R723 VDDd.n140 VDDd.n139 6.3005
R724 VDDd.n132 VDDd.n131 6.3005
R725 VDDd.n138 VDDd.n131 6.3005
R726 VDDd.n158 VDDd.n153 6.3005
R727 VDDd.n159 VDDd.n158 6.3005
R728 VDDd.n157 VDDd.n156 6.3005
R729 VDDd.n188 VDDd.n183 6.3005
R730 VDDd.n189 VDDd.n188 6.3005
R731 VDDd.n187 VDDd.n186 6.3005
R732 VDDd.n217 VDDd.n216 6.3005
R733 VDDd.n215 VDDd.n214 6.3005
R734 VDDd.n219 VDDd.n214 6.3005
R735 VDDd.n241 VDDd.n240 6.3005
R736 VDDd.n240 VDDd.n239 6.3005
R737 VDDd.n236 VDDd.n235 6.3005
R738 VDDd.n4 VDDd.t4 6.22272
R739 VDDd.n75 VDDd.t6 6.0485
R740 VDDd.n68 VDDd.t91 6.0485
R741 VDDd.n119 VDDd.t51 6.0485
R742 VDDd.n112 VDDd.t20 6.0485
R743 VDDd.n169 VDDd.t9 6.0485
R744 VDDd.n162 VDDd.t176 6.0485
R745 VDDd.n199 VDDd.t112 6.0485
R746 VDDd.n192 VDDd.t76 6.0485
R747 VDDd.n229 VDDd.t96 6.0485
R748 VDDd.n222 VDDd.t40 6.0485
R749 VDDd.n99 VDDd.t5 5.94673
R750 VDDd.n143 VDDd.t44 5.94673
R751 VDDd.n98 VDDd.t90 5.68819
R752 VDDd.n142 VDDd.t19 5.68819
R753 VDDd.n64 VDDd 5.65727
R754 VDDd VDDd.n46 5.30506
R755 VDDd VDDd.n39 5.30506
R756 VDDd.n2 VDDd.n1 5.2005
R757 VDDd.n5 VDDd.n4 5.2005
R758 VDDd.n7 VDDd.n6 5.2005
R759 VDDd.n41 VDDd.n40 5.2005
R760 VDDd.n48 VDDd.n47 5.2005
R761 VDDd.n4 VDDd.t72 5.05606
R762 VDDd.n64 VDDd 4.51775
R763 VDDd.n108 VDDd 4.51775
R764 VDDd.n152 VDDd 4.51775
R765 VDDd.n211 VDDd 4.51775
R766 VDDd.n182 VDDd.n181 4.50204
R767 VDDd VDDd.n212 4.50155
R768 VDDd VDDd.n36 4.35925
R769 VDDd VDDd.n173 4.35925
R770 VDDd VDDd.n160 4.35925
R771 VDDd VDDd.n203 4.35925
R772 VDDd VDDd.n190 4.35925
R773 VDDd VDDd.n233 4.35925
R774 VDDd VDDd.n220 4.35925
R775 VDDd.n8 VDDd.t117 4.0923
R776 VDDd.n67 VDDd.t58 4.0923
R777 VDDd.n77 VDDd.t50 4.0923
R778 VDDd.n111 VDDd.t68 4.0923
R779 VDDd.n121 VDDd.t108 4.0923
R780 VDDd.n161 VDDd.t159 4.0923
R781 VDDd.n171 VDDd.t98 4.0923
R782 VDDd.n172 VDDd.t64 4.0923
R783 VDDd.n174 VDDd.t31 4.0923
R784 VDDd.n191 VDDd.t190 4.0923
R785 VDDd.n201 VDDd.t152 4.0923
R786 VDDd.n202 VDDd.t145 4.0923
R787 VDDd.n204 VDDd.t119 4.0923
R788 VDDd.n221 VDDd.t178 4.0923
R789 VDDd.n231 VDDd.t83 4.0923
R790 VDDd.n232 VDDd.t133 4.0923
R791 VDDd.n234 VDDd.t62 4.0923
R792 VDDd.n14 VDDd.n13 2.96571
R793 VDDd.n12 VDDd.n10 2.96571
R794 VDDd.n34 VDDd.n33 2.96571
R795 VDDd.n55 VDDd.n52 2.96571
R796 VDDd.n157 VDDd.n154 2.96571
R797 VDDd.n187 VDDd.n184 2.96571
R798 VDDd.n218 VDDd.n217 2.96571
R799 VDDd.n238 VDDd.n236 2.96571
R800 VDDd.n46 VDDd.t37 2.95985
R801 VDDd.n46 VDDd.t131 2.95985
R802 VDDd.n39 VDDd.t184 2.95985
R803 VDDd.n39 VDDd.t78 2.95985
R804 VDDd.n40 VDDd.t33 2.95985
R805 VDDd.n40 VDDd.t149 2.95985
R806 VDDd.n47 VDDd.t11 2.95985
R807 VDDd.n47 VDDd.t47 2.95985
R808 VDDd.n80 VDDd.n79 2.94475
R809 VDDd.n84 VDDd.n81 2.94475
R810 VDDd.n124 VDDd.n123 2.94475
R811 VDDd.n128 VDDd.n125 2.94475
R812 VDDd.n70 VDDd.t126 2.72482
R813 VDDd.n73 VDDd.t29 2.72482
R814 VDDd.n114 VDDd.t80 2.72482
R815 VDDd.n117 VDDd.t157 2.72482
R816 VDDd.n164 VDDd.t15 2.72482
R817 VDDd.n167 VDDd.t56 2.72482
R818 VDDd.n194 VDDd.t125 2.72482
R819 VDDd.n197 VDDd.t105 2.72482
R820 VDDd.n224 VDDd.t43 2.72482
R821 VDDd.n227 VDDd.t140 2.72482
R822 VDDd.n50 VDDd.n49 2.6005
R823 VDDd.n43 VDDd.n42 2.6005
R824 VDDd.n38 VDDd.n37 2.6005
R825 VDDd.n45 VDDd.n44 2.6005
R826 VDDd.n76 VDDd.n75 2.6005
R827 VDDd.n71 VDDd.n70 2.6005
R828 VDDd.n69 VDDd.n68 2.6005
R829 VDDd.n74 VDDd.n73 2.6005
R830 VDDd.n120 VDDd.n119 2.6005
R831 VDDd.n115 VDDd.n114 2.6005
R832 VDDd.n113 VDDd.n112 2.6005
R833 VDDd.n118 VDDd.n117 2.6005
R834 VDDd.n170 VDDd.n169 2.6005
R835 VDDd.n165 VDDd.n164 2.6005
R836 VDDd.n163 VDDd.n162 2.6005
R837 VDDd.n168 VDDd.n167 2.6005
R838 VDDd.n200 VDDd.n199 2.6005
R839 VDDd.n195 VDDd.n194 2.6005
R840 VDDd.n193 VDDd.n192 2.6005
R841 VDDd.n198 VDDd.n197 2.6005
R842 VDDd.n230 VDDd.n229 2.6005
R843 VDDd.n225 VDDd.n224 2.6005
R844 VDDd.n223 VDDd.n222 2.6005
R845 VDDd.n228 VDDd.n227 2.6005
R846 VDDd.n6 VDDd.t13 2.2755
R847 VDDd.n1 VDDd.t102 2.10455
R848 VDDd.n1 VDDd.t110 2.10455
R849 VDDd.n75 VDDd.t163 2.01467
R850 VDDd.n68 VDDd.t52 2.01467
R851 VDDd.n119 VDDd.t66 2.01467
R852 VDDd.n112 VDDd.t27 2.01467
R853 VDDd.n169 VDDd.t93 2.01467
R854 VDDd.n162 VDDd.t17 2.01467
R855 VDDd.n199 VDDd.t128 2.01467
R856 VDDd.n192 VDDd.t88 2.01467
R857 VDDd.n229 VDDd.t138 2.01467
R858 VDDd.n222 VDDd.t171 2.01467
R859 VDDd.n70 VDDd.t60 1.96807
R860 VDDd.n73 VDDd.t48 1.96807
R861 VDDd.n114 VDDd.t70 1.96807
R862 VDDd.n117 VDDd.t106 1.96807
R863 VDDd.n164 VDDd.t161 1.96807
R864 VDDd.n167 VDDd.t100 1.96807
R865 VDDd.n194 VDDd.t192 1.96807
R866 VDDd.n197 VDDd.t154 1.96807
R867 VDDd.n224 VDDd.t180 1.96807
R868 VDDd.n227 VDDd.t85 1.96807
R869 VDDd.n81 VDDd.n66 1.8708
R870 VDDd.n101 VDDd.n79 1.8708
R871 VDDd.n125 VDDd.n110 1.8708
R872 VDDd.n145 VDDd.n123 1.8708
R873 VDDd.n49 VDDd.t22 1.71808
R874 VDDd.n42 VDDd.t173 1.71808
R875 VDDd.n37 VDDd.t143 1.71808
R876 VDDd.n44 VDDd.t182 1.71808
R877 VDDd.n18 VDDd.n13 1.66865
R878 VDDd.n20 VDDd.n12 1.66865
R879 VDDd.n35 VDDd.n34 1.66865
R880 VDDd.n57 VDDd.n52 1.66865
R881 VDDd.n159 VDDd.n154 1.66865
R882 VDDd.n189 VDDd.n184 1.66865
R883 VDDd.n219 VDDd.n218 1.66865
R884 VDDd.n239 VDDd.n238 1.66865
R885 VDDd.n108 VDDd.n64 1.14002
R886 VDDd.n182 VDDd.n152 1.14002
R887 VDDd.n212 VDDd.n211 1.14002
R888 VDDd.n152 VDDd.n108 1.13711
R889 VDDd.n211 VDDd.n182 1.13566
R890 VDDd.n25 VDDd.n24 0.7415
R891 VDDd.n26 VDDd.n25 0.6575
R892 VDDd.n212 VDDd 0.613081
R893 VDDd.n105 VDDd 0.6005
R894 VDDd.n149 VDDd 0.6005
R895 VDDd.n178 VDDd 0.6005
R896 VDDd.n208 VDDd 0.6005
R897 VDDd.n246 VDDd 0.6005
R898 VDDd VDDd.n59 0.549426
R899 VDDd VDDd.n61 0.547938
R900 VDDd VDDd.n174 0.321891
R901 VDDd VDDd.n204 0.321891
R902 VDDd.n27 VDDd.n26 0.2915
R903 VDDd.n104 VDDd 0.2915
R904 VDDd.n106 VDDd 0.2915
R905 VDDd.n148 VDDd 0.2915
R906 VDDd.n150 VDDd 0.2915
R907 VDDd.n177 VDDd 0.2915
R908 VDDd.n179 VDDd 0.2915
R909 VDDd.n207 VDDd 0.2915
R910 VDDd.n209 VDDd 0.2915
R911 VDDd.n245 VDDd 0.2915
R912 VDDd.n247 VDDd 0.2915
R913 VDDd.n242 VDDd 0.2675
R914 VDDd.n23 VDDd 0.2645
R915 VDDd.n24 VDDd.n23 0.2615
R916 VDDd.t59 VDDd.t162 0.259032
R917 VDDd.t53 VDDd.t90 0.259032
R918 VDDd.t69 VDDd.t65 0.259032
R919 VDDd.t18 VDDd.t19 0.259032
R920 VDDd.n175 VDDd.n172 0.252891
R921 VDDd.n205 VDDd.n202 0.252891
R922 VDDd.n243 VDDd.n232 0.252891
R923 VDDd.n242 VDDd.n234 0.252891
R924 VDDd VDDd.n27 0.2225
R925 VDDd VDDd.n60 0.220665
R926 VDDd VDDd.n62 0.220665
R927 VDDd.n103 VDDd 0.209848
R928 VDDd.n147 VDDd 0.209848
R929 VDDd.n176 VDDd 0.209848
R930 VDDd.n206 VDDd 0.209848
R931 VDDd.n244 VDDd 0.209848
R932 VDDd VDDd.n50 0.178543
R933 VDDd VDDd.n43 0.178543
R934 VDDd.n62 VDDd.n38 0.178543
R935 VDDd.n60 VDDd.n45 0.178543
R936 VDDd VDDd.n76 0.178543
R937 VDDd VDDd.n71 0.178543
R938 VDDd.n106 VDDd.n69 0.178543
R939 VDDd.n104 VDDd.n74 0.178543
R940 VDDd VDDd.n120 0.178543
R941 VDDd VDDd.n115 0.178543
R942 VDDd.n150 VDDd.n113 0.178543
R943 VDDd.n148 VDDd.n118 0.178543
R944 VDDd VDDd.n170 0.178543
R945 VDDd VDDd.n165 0.178543
R946 VDDd.n179 VDDd.n163 0.178543
R947 VDDd.n177 VDDd.n168 0.178543
R948 VDDd VDDd.n200 0.178543
R949 VDDd VDDd.n195 0.178543
R950 VDDd.n209 VDDd.n193 0.178543
R951 VDDd.n207 VDDd.n198 0.178543
R952 VDDd VDDd.n230 0.178543
R953 VDDd VDDd.n225 0.178543
R954 VDDd.n247 VDDd.n223 0.178543
R955 VDDd.n245 VDDd.n228 0.178543
R956 VDDd.n172 VDDd 0.17463
R957 VDDd.n174 VDDd 0.17463
R958 VDDd.n202 VDDd 0.17463
R959 VDDd.n204 VDDd 0.17463
R960 VDDd.n232 VDDd 0.17463
R961 VDDd.n234 VDDd 0.17463
R962 VDDd.n24 VDDd 0.170717
R963 VDDd.n23 VDDd 0.170717
R964 VDDd.n15 VDDd.n0 0.169912
R965 VDDd.n16 VDDd.n15 0.169912
R966 VDDd.n22 VDDd.n9 0.169912
R967 VDDd.n11 VDDd.n9 0.169912
R968 VDDd.n32 VDDd.n29 0.169912
R969 VDDd.n32 VDDd.n31 0.169912
R970 VDDd.n54 VDDd.n51 0.169912
R971 VDDd.n54 VDDd.n53 0.169912
R972 VDDd.n91 VDDd.n65 0.169912
R973 VDDd.n92 VDDd.n91 0.169912
R974 VDDd.n89 VDDd.n78 0.169912
R975 VDDd.n89 VDDd.n88 0.169912
R976 VDDd.n135 VDDd.n109 0.169912
R977 VDDd.n136 VDDd.n135 0.169912
R978 VDDd.n133 VDDd.n122 0.169912
R979 VDDd.n133 VDDd.n132 0.169912
R980 VDDd.n156 VDDd.n153 0.169912
R981 VDDd.n156 VDDd.n155 0.169912
R982 VDDd.n186 VDDd.n183 0.169912
R983 VDDd.n186 VDDd.n185 0.169912
R984 VDDd.n216 VDDd.n213 0.169912
R985 VDDd.n216 VDDd.n215 0.169912
R986 VDDd.n241 VDDd.n235 0.169912
R987 VDDd.n237 VDDd.n235 0.169912
R988 VDDd VDDd.n22 0.145029
R989 VDDd VDDd.n241 0.145029
R990 VDDd.n105 VDDd.n72 0.143326
R991 VDDd.n149 VDDd.n116 0.143326
R992 VDDd.n178 VDDd.n166 0.143326
R993 VDDd.n208 VDDd.n196 0.143326
R994 VDDd.n246 VDDd.n226 0.143326
R995 VDDd VDDd.n103 0.1385
R996 VDDd VDDd.n106 0.1385
R997 VDDd VDDd.n147 0.1385
R998 VDDd VDDd.n150 0.1385
R999 VDDd VDDd.n176 0.1385
R1000 VDDd VDDd.n179 0.1385
R1001 VDDd VDDd.n206 0.1385
R1002 VDDd VDDd.n209 0.1385
R1003 VDDd VDDd.n244 0.1385
R1004 VDDd VDDd.n247 0.1385
R1005 VDDd.n67 VDDd 0.123761
R1006 VDDd.n77 VDDd 0.123761
R1007 VDDd.n111 VDDd 0.123761
R1008 VDDd.n121 VDDd 0.123761
R1009 VDDd.n161 VDDd 0.123761
R1010 VDDd.n171 VDDd 0.123761
R1011 VDDd.n191 VDDd 0.123761
R1012 VDDd.n201 VDDd 0.123761
R1013 VDDd.n221 VDDd 0.123761
R1014 VDDd.n231 VDDd 0.123761
R1015 VDDd.n27 VDDd 0.115647
R1016 VDDd.n25 VDDd 0.115647
R1017 VDDd.n61 VDDd.n41 0.105059
R1018 VDDd.n59 VDDd.n48 0.105059
R1019 VDDd.n26 VDDd.n3 0.104196
R1020 VDDd.n28 VDDd 0.0875
R1021 VDDd.n181 VDDd.n180 0.0819844
R1022 VDDd VDDd.n28 0.0815
R1023 VDDd VDDd.n102 0.0815
R1024 VDDd VDDd.n107 0.0815
R1025 VDDd VDDd.n146 0.0815
R1026 VDDd VDDd.n151 0.0815
R1027 VDDd VDDd.n210 0.0815
R1028 VDDd VDDd.n248 0.0814908
R1029 VDDd VDDd.n58 0.0808306
R1030 VDDd VDDd.n63 0.0808306
R1031 VDDd.n103 VDDd 0.0695
R1032 VDDd.n147 VDDd 0.0695
R1033 VDDd VDDd.n175 0.0695
R1034 VDDd.n176 VDDd 0.0695
R1035 VDDd VDDd.n205 0.0695
R1036 VDDd.n206 VDDd 0.0695
R1037 VDDd VDDd.n242 0.0695
R1038 VDDd VDDd.n243 0.0695
R1039 VDDd.n244 VDDd 0.0695
R1040 VDDd.n3 VDDd 0.0670217
R1041 VDDd.n72 VDDd 0.0670217
R1042 VDDd.n116 VDDd 0.0670217
R1043 VDDd.n166 VDDd 0.0670217
R1044 VDDd.n196 VDDd 0.0670217
R1045 VDDd.n226 VDDd 0.0670217
R1046 VDDd.n8 VDDd 0.0650652
R1047 VDDd.n28 VDDd.n0 0.0640294
R1048 VDDd.n63 VDDd.n29 0.0640294
R1049 VDDd.n58 VDDd.n51 0.0640294
R1050 VDDd VDDd.n66 0.0640294
R1051 VDDd VDDd.n101 0.0640294
R1052 VDDd.n107 VDDd.n65 0.0640294
R1053 VDDd.n102 VDDd.n78 0.0640294
R1054 VDDd VDDd.n110 0.0640294
R1055 VDDd VDDd.n145 0.0640294
R1056 VDDd.n151 VDDd.n109 0.0640294
R1057 VDDd.n146 VDDd.n122 0.0640294
R1058 VDDd.n180 VDDd.n153 0.0640294
R1059 VDDd.n210 VDDd.n183 0.0640294
R1060 VDDd.n248 VDDd.n213 0.0640294
R1061 VDDd.n7 VDDd 0.0631087
R1062 VDDd.n16 VDDd 0.0481471
R1063 VDDd.n11 VDDd 0.0481471
R1064 VDDd.n31 VDDd 0.0481471
R1065 VDDd.n53 VDDd 0.0481471
R1066 VDDd.n92 VDDd 0.0481471
R1067 VDDd.n88 VDDd 0.0481471
R1068 VDDd.n136 VDDd 0.0481471
R1069 VDDd.n132 VDDd 0.0481471
R1070 VDDd.n155 VDDd 0.0481471
R1071 VDDd.n185 VDDd 0.0481471
R1072 VDDd.n215 VDDd 0.0481471
R1073 VDDd.n237 VDDd 0.0481471
R1074 VDDd.n61 VDDd 0.0481033
R1075 VDDd.n62 VDDd 0.0481033
R1076 VDDd.n59 VDDd 0.0466157
R1077 VDDd.n60 VDDd 0.0466157
R1078 VDDd VDDd.n67 0.0435435
R1079 VDDd VDDd.n77 0.0435435
R1080 VDDd VDDd.n111 0.0435435
R1081 VDDd VDDd.n121 0.0435435
R1082 VDDd VDDd.n161 0.0435435
R1083 VDDd VDDd.n171 0.0435435
R1084 VDDd VDDd.n191 0.0435435
R1085 VDDd VDDd.n201 0.0435435
R1086 VDDd VDDd.n221 0.0435435
R1087 VDDd VDDd.n231 0.0435435
R1088 VDDd VDDd.n104 0.0425
R1089 VDDd VDDd.n105 0.0425
R1090 VDDd VDDd.n148 0.0425
R1091 VDDd VDDd.n149 0.0425
R1092 VDDd VDDd.n177 0.0425
R1093 VDDd VDDd.n178 0.0425
R1094 VDDd VDDd.n207 0.0425
R1095 VDDd VDDd.n208 0.0425
R1096 VDDd VDDd.n245 0.0425
R1097 VDDd VDDd.n246 0.0425
R1098 VDDd VDDd.n2 0.0375588
R1099 VDDd VDDd.n8 0.0357174
R1100 VDDd.n41 VDDd 0.0322647
R1101 VDDd.n48 VDDd 0.0322647
R1102 VDDd.n76 VDDd 0.0318043
R1103 VDDd.n71 VDDd 0.0318043
R1104 VDDd.n69 VDDd 0.0318043
R1105 VDDd.n74 VDDd 0.0318043
R1106 VDDd.n120 VDDd 0.0318043
R1107 VDDd.n115 VDDd 0.0318043
R1108 VDDd.n113 VDDd 0.0318043
R1109 VDDd.n118 VDDd 0.0318043
R1110 VDDd.n170 VDDd 0.0318043
R1111 VDDd.n165 VDDd 0.0318043
R1112 VDDd.n163 VDDd 0.0318043
R1113 VDDd.n168 VDDd 0.0318043
R1114 VDDd.n200 VDDd 0.0318043
R1115 VDDd.n195 VDDd 0.0318043
R1116 VDDd.n193 VDDd 0.0318043
R1117 VDDd.n198 VDDd 0.0318043
R1118 VDDd.n230 VDDd 0.0318043
R1119 VDDd.n225 VDDd 0.0318043
R1120 VDDd.n223 VDDd 0.0318043
R1121 VDDd.n228 VDDd 0.0318043
R1122 VDDd.n2 VDDd 0.0309412
R1123 VDDd VDDd.n5 0.0309412
R1124 VDDd.n5 VDDd 0.0309412
R1125 VDDd VDDd.n7 0.0278913
R1126 VDDd.n50 VDDd 0.0239783
R1127 VDDd.n43 VDDd 0.0239783
R1128 VDDd.n38 VDDd 0.0239783
R1129 VDDd.n45 VDDd 0.0239783
R1130 VDDd.n175 VDDd 0.0185
R1131 VDDd.n205 VDDd 0.0185
R1132 VDDd.n243 VDDd 0.0185
R1133 VDDd.n102 VDDd 0.0065
R1134 VDDd.n107 VDDd 0.0065
R1135 VDDd.n146 VDDd 0.0065
R1136 VDDd.n151 VDDd 0.0065
R1137 VDDd.n180 VDDd 0.0065
R1138 VDDd.n210 VDDd 0.0065
R1139 VDDd.n248 VDDd 0.0065
R1140 VDDd.n63 VDDd 0.00645041
R1141 VDDd.n58 VDDd 0.00496281
R1142 VDDd.n181 VDDd 0.00100643
R1143 a_122_1806.n0 a_122_1806.t3 121.874
R1144 a_122_1806.t3 a_122_1806.t6 61.5152
R1145 a_122_1806.n2 a_122_1806.t5 52.378
R1146 a_122_1806.n2 a_122_1806.t7 17.7152
R1147 a_122_1806.t0 a_122_1806.n4 11.1158
R1148 a_122_1806.n1 a_122_1806.n0 9.95623
R1149 a_122_1806.n1 a_122_1806.t1 8.02846
R1150 a_122_1806.n4 a_122_1806.n3 8.0005
R1151 a_122_1806.n0 a_122_1806.t4 6.7165
R1152 a_122_1806.n3 a_122_1806.t2 6.023
R1153 a_122_1806.n3 a_122_1806.n2 1.33883
R1154 a_122_1806.n4 a_122_1806.n1 0.376152
R1155 CLK1.n0 CLK1.t1 17.192
R1156 CLK1.n24 CLK1.t8 16.4377
R1157 CLK1.n19 CLK1.t6 16.4377
R1158 CLK1.n13 CLK1.t0 16.4377
R1159 CLK1.n7 CLK1.t2 16.4377
R1160 CLK1.n2 CLK1.t7 16.4377
R1161 CLK1.n24 CLK1.t4 15.7563
R1162 CLK1.n19 CLK1.t9 15.7563
R1163 CLK1.n13 CLK1.t10 15.7563
R1164 CLK1.n7 CLK1.t3 15.7563
R1165 CLK1.n2 CLK1.t11 15.7563
R1166 CLK1.n0 CLK1.t5 12.3497
R1167 CLK1.n25 CLK1.n24 8.21425
R1168 CLK1.n20 CLK1.n19 8.21425
R1169 CLK1.n14 CLK1.n13 8.21425
R1170 CLK1.n8 CLK1.n7 8.21425
R1171 CLK1.n3 CLK1.n2 8.21425
R1172 CLK1.n11 CLK1.n1 5.33286
R1173 CLK1.n5 CLK1.n4 4.8358
R1174 CLK1.n27 CLK1.n26 4.50566
R1175 CLK1.n10 CLK1.n9 4.5005
R1176 CLK1.n16 CLK1.n15 4.5005
R1177 CLK1.n22 CLK1.n21 4.5005
R1178 CLK1.n1 CLK1.n0 4.0005
R1179 CLK1.n23 CLK1 3.96868
R1180 CLK1.n17 CLK1 2.6825
R1181 CLK1.n27 CLK1 2.37425
R1182 CLK1.n11 CLK1 1.40123
R1183 CLK1.n18 CLK1.n17 1.16805
R1184 CLK1.n28 CLK1.n23 1.16477
R1185 CLK1.n12 CLK1.n11 1.16314
R1186 CLK1.n6 CLK1.n5 1.14841
R1187 CLK1 CLK1.n28 0.790108
R1188 CLK1.n18 CLK1 0.591911
R1189 CLK1.n12 CLK1 0.394313
R1190 CLK1.n1 CLK1 0.156962
R1191 CLK1.n5 CLK1 0.134682
R1192 CLK1.n6 CLK1 0.12166
R1193 CLK1.n25 CLK1 0.107375
R1194 CLK1.n20 CLK1 0.107375
R1195 CLK1.n14 CLK1 0.107375
R1196 CLK1.n8 CLK1 0.107375
R1197 CLK1.n3 CLK1 0.107375
R1198 CLK1.n4 CLK1 0.0976053
R1199 CLK1.n26 CLK1 0.0952368
R1200 CLK1.n15 CLK1 0.0905
R1201 CLK1.n9 CLK1 0.0881316
R1202 CLK1.n21 CLK1 0.0857632
R1203 CLK1.n21 CLK1 0.0644474
R1204 CLK1.n9 CLK1 0.0620789
R1205 CLK1.n15 CLK1 0.0597105
R1206 CLK1.n26 CLK1 0.0549737
R1207 CLK1.n4 CLK1 0.0526053
R1208 CLK1 CLK1.n25 0.0383947
R1209 CLK1 CLK1.n20 0.0383947
R1210 CLK1 CLK1.n14 0.0383947
R1211 CLK1 CLK1.n8 0.0383947
R1212 CLK1 CLK1.n3 0.0383947
R1213 CLK1.n5 CLK1 0.0306829
R1214 CLK1.n16 CLK1.n12 0.0105559
R1215 CLK1.n23 CLK1.n22 0.00967598
R1216 CLK1.n22 CLK1.n18 0.00955028
R1217 CLK1.n17 CLK1.n16 0.00867039
R1218 CLK1.n10 CLK1.n6 0.00637629
R1219 CLK1.n11 CLK1.n10 0.00583505
R1220 CLK1.n28 CLK1.n27 0.00540909
R1221 CLK2_BUFF.n1 CLK2_BUFF.t1 8.29806
R1222 CLK2_BUFF.n0 CLK2_BUFF 4.63951
R1223 CLK2_BUFF.n0 CLK2_BUFF.t0 4.62003
R1224 CLK2_BUFF CLK2_BUFF.n1 0.0864091
R1225 CLK2_BUFF.n1 CLK2_BUFF.n0 0.0536818
R1226 CLK2.n0 CLK2.t5 17.192
R1227 CLK2.n21 CLK2.t8 16.4377
R1228 CLK2.n17 CLK2.t2 16.4377
R1229 CLK2.n12 CLK2.t11 16.4377
R1230 CLK2.n7 CLK2.t3 16.4377
R1231 CLK2.n2 CLK2.t7 16.4377
R1232 CLK2.n21 CLK2.t4 15.7563
R1233 CLK2.n17 CLK2.t9 15.7563
R1234 CLK2.n12 CLK2.t1 15.7563
R1235 CLK2.n7 CLK2.t6 15.7563
R1236 CLK2.n2 CLK2.t10 15.7563
R1237 CLK2.n0 CLK2.t0 12.3497
R1238 CLK2.n4 CLK2.n1 8.58775
R1239 CLK2.n22 CLK2.n21 8.0005
R1240 CLK2.n18 CLK2.n17 8.0005
R1241 CLK2.n13 CLK2.n12 8.0005
R1242 CLK2.n8 CLK2.n7 8.0005
R1243 CLK2.n3 CLK2.n2 8.0005
R1244 CLK2.n4 CLK2 4.51518
R1245 CLK2.n23 CLK2 4.51376
R1246 CLK2.n19 CLK2 4.51376
R1247 CLK2.n14 CLK2 4.51376
R1248 CLK2.n9 CLK2 4.51376
R1249 CLK2.n1 CLK2.n0 4.09327
R1250 CLK2.n20 CLK2 4.00632
R1251 CLK2.n15 CLK2 2.72259
R1252 CLK2.n23 CLK2 2.39175
R1253 CLK2 CLK2.n24 1.56875
R1254 CLK2.n10 CLK2 1.4405
R1255 CLK2.n16 CLK2 1.17675
R1256 CLK2.n6 CLK2.n5 1.12795
R1257 CLK2.n16 CLK2.n15 1.12795
R1258 CLK2.n24 CLK2.n20 1.12714
R1259 CLK2.n11 CLK2.n10 1.12632
R1260 CLK2.n11 CLK2 0.7845
R1261 CLK2.n6 CLK2 0.39275
R1262 CLK2 CLK2.n22 0.21425
R1263 CLK2 CLK2.n18 0.21425
R1264 CLK2 CLK2.n13 0.21425
R1265 CLK2 CLK2.n8 0.21425
R1266 CLK2 CLK2.n3 0.21425
R1267 CLK2.n5 CLK2 0.156773
R1268 CLK2.n5 CLK2.n4 0.120186
R1269 CLK2.n1 CLK2 0.0641923
R1270 CLK2.n22 CLK2 0.0525312
R1271 CLK2.n18 CLK2 0.0525312
R1272 CLK2.n13 CLK2 0.0525312
R1273 CLK2.n8 CLK2 0.0525312
R1274 CLK2.n3 CLK2 0.0525312
R1275 CLK2.n5 CLK2 0.0264162
R1276 CLK2.n10 CLK2.n9 0.02475
R1277 CLK2.n14 CLK2.n11 0.0245
R1278 CLK2.n20 CLK2.n19 0.0245
R1279 CLK2.n24 CLK2.n23 0.0245
R1280 CLK2.n15 CLK2.n14 0.02425
R1281 CLK2.n19 CLK2.n16 0.02425
R1282 CLK2.n9 CLK2.n6 0.024
R1283 IN[1].n5 IN[1].t0 24.0436
R1284 IN[1].n0 IN[1].t5 24.0436
R1285 IN[1].n7 IN[1].t7 19.133
R1286 IN[1].n1 IN[1].t3 19.133
R1287 IN[1].n6 IN[1].t2 16.9795
R1288 IN[1].n3 IN[1].t6 16.9795
R1289 IN[1].n5 IN[1].t4 8.9795
R1290 IN[1].n0 IN[1].t1 8.9795
R1291 IN[1].n6 IN[1].n5 8.37321
R1292 IN[1].n4 IN[1].n0 8.06826
R1293 IN[1].n11 IN[1].n4 5.1055
R1294 IN[1].n10 IN[1].n9 3.39888
R1295 IN[1].n10 IN[1] 2.36525
R1296 IN[1].n4 IN[1].n3 0.305441
R1297 IN[1].n3 IN[1].n2 0.221794
R1298 IN[1].n8 IN[1].n7 0.189373
R1299 IN[1].n2 IN[1].n1 0.189373
R1300 IN[1].n9 IN[1].n8 0.176265
R1301 IN[1].n11 IN[1].n10 0.0815
R1302 IN[1].n9 IN[1].n6 0.0460294
R1303 IN[1].n7 IN[1] 0.0435986
R1304 IN[1].n1 IN[1] 0.0435986
R1305 IN[1].n8 IN[1] 0.0375588
R1306 IN[1].n2 IN[1] 0.0375588
R1307 IN[1] IN[1].n11 0.03425
R1308 CLK_CLB.n0 CLK_CLB.t0 13.907
R1309 CLK_CLB.n0 CLK_CLB.t1 12.0455
R1310 CLK_CLB.n1 CLK_CLB.n0 8.0005
R1311 CLK_CLB.n1 CLK_CLB 4.66392
R1312 CLK_CLB CLK_CLB.n1 0.0597105
R1313 D.n0 D.t0 26.8402
R1314 D.n0 D.t1 8.88217
R1315 D.n1 D.n0 8.0005
R1316 D.n3 D 2.37425
R1317 D.n3 D.n2 2.27863
R1318 D D.n3 0.12425
R1319 D.n2 D 0.121437
R1320 D.n1 D 0.0334703
R1321 D.n2 D.n1 0.00584653
R1322 OUT.n0 OUT.t1 8.52154
R1323 OUT.n1 OUT.t0 4.0923
R1324 OUT.n0 OUT 2.45599
R1325 OUT.n1 OUT.n0 0.161287
R1326 OUT OUT.n1 0.100612
R1327 Q.n0 Q.t1 8.29806
R1328 Q.n2 Q 4.59693
R1329 Q.n2 Q.n1 4.5005
R1330 Q.n1 Q.t0 4.10594
R1331 Q.n1 Q.n0 0.567773
R1332 Q Q.n2 0.0969286
R1333 Q.n0 Q 0.0864091
R1334 CLK1_BUFF.n1 CLK1_BUFF.t1 8.29806
R1335 CLK1_BUFF.n0 CLK1_BUFF 4.65929
R1336 CLK1_BUFF.n0 CLK1_BUFF.t0 4.17003
R1337 CLK1_BUFF.n1 CLK1_BUFF.n0 0.503682
R1338 CLK1_BUFF CLK1_BUFF.n1 0.0864091
C0 lut_0.REG[2] a_1406_n3766# 0
C1 lut_0.REG[4] a_1062_n1926# 0.15144f
C2 reg_bank_5bit_0.gf180mcu_fd_sc_mcu7t5v0__latq_1_0.D CLK1 0.12955f
C3 a_490_n93# CLK1 0.00441f
C4 a_1062_n6630# CLK1 0.44456f
C5 a_210_n6543# CLK2 0.10427f
C6 reg_bank_5bit_0.gf180mcu_fd_sc_mcu7t5v0__latq_1_5.D a_1106_n5596# 0.02873f
C7 lut_0.REG[1] a_1490_n4576# 0.02966f
C8 reg_bank_5bit_0.gf180mcu_fd_sc_mcu7t5v0__latq_1_3.D a_122_n1395# 0.18817f
C9 gf180mcu_fd_sc_mcu7t5v0__mux2_1_0.S a_2052_1479# 0
C10 a_166_1479# IN[1] 0.01977f
C11 a_958_n2964# CLK1 0
C12 gf180mcu_fd_sc_mcu7t5v0__mux2_1_0.S a_958_n2460# 0
C13 lut_0.REG[1] a_122_n1395# 0.00198f
C14 a_1090_1814# a_2097_2182# 0
C15 gf180mcu_fd_sc_mcu7t5v0__mux2_1_0.S a_1310_n7164# 0.00375f
C16 VDDd CLK1 2.74989f
C17 a_534_2127# a_2382_2182# 0
C18 lut_0.gf180mcu_fd_sc_mcu7t5v0__mux2_1_2.Z a_678_493# 0.00675f
C19 gf180mcu_fd_sc_mcu7t5v0__mux2_1_0.I1 a_2134_493# 0.00108f
C20 lut_0.REG[3] a_1102_n3810# 0.40965f
C21 gf180mcu_fd_sc_mcu7t5v0__mux2_1_0.S a_1490_n4576# 0.01728f
C22 lut_0.REG[2] a_122_n2963# 0
C23 lut_0.REG[1] a_1310_n892# 0.00336f
C24 a_1062_n358# D 0.13585f
C25 gf180mcu_fd_sc_mcu7t5v0__mux2_1_0.S a_122_n1395# 0.02813f
C26 a_210_n271# IN[1] 0.01158f
C27 a_210_110# IN[1] 0.22263f
C28 lut_0.REG[1] a_1106_n2460# 0.01677f
C29 a_1102_n6946# a_1106_n7164# 0.00202f
C30 a_166_1479# a_598_1479# 0.00166f
C31 lut_0.gf180mcu_fd_sc_mcu7t5v0__mux2_1_2.Z a_746_939# 0.51585f
C32 lut_0.REG[2] a_210_n271# 0.00283f
C33 a_210_n1839# CLK1 0.05446f
C34 a_678_493# reg_bank_5bit_0.gf180mcu_fd_sc_mcu7t5v0__latq_1_3.D 0.00345f
C35 a_958_n6100# CLK2 0
C36 a_490_n6365# CLK1 0.00953f
C37 lut_0.REG[1] a_678_493# 0.09678f
C38 a_210_110# lut_0.REG[2] 0.00475f
C39 a_1666_110# CLK1 0.00165f
C40 a_1062_n358# a_1102_n2242# 0
C41 reg_bank_5bit_0.gf180mcu_fd_sc_mcu7t5v0__inv_1_0.ZN VDDd 0.52972f
C42 lut_0.REG[1] a_570_n4027# 0
C43 a_1350_n2964# CLK1 0.00178f
C44 gf180mcu_fd_sc_mcu7t5v0__mux2_1_0.S a_1106_n2460# 0.00786f
C45 lut_0.REG[1] a_1406_n630# 0
C46 gf180mcu_fd_sc_mcu7t5v0__mux2_1_0.S a_958_n7164# 0
C47 a_534_2127# a_1434_2182# 0
C48 a_1462_1770# a_2097_2182# 0.02112f
C49 a_1406_n79# CLK1 0
C50 lut_0.LUT_OUT a_966_2182# 0.00187f
C51 CLK1 CLK2 0.38126f
C52 gf180mcu_fd_sc_mcu7t5v0__inv_1_3.ZN CLK1 0.33664f
C53 gf180mcu_fd_sc_mcu7t5v0__mux2_1_0.S a_678_493# 0.00804f
C54 gf180mcu_fd_sc_mcu7t5v0__mux2_1_0.S a_2052_939# 0.00474f
C55 lut_0.REG[3] a_1062_n3494# 0.1447f
C56 lut_0.REG[2] a_1406_n2198# 0
C57 gf180mcu_fd_sc_mcu7t5v0__mux2_1_0.S OUT 0.03159f
C58 gf180mcu_fd_sc_mcu7t5v0__mux2_1_0.S a_570_n4027# 0.01665f
C59 lut_0.REG[3] D 0
C60 lut_0.REG[2] a_1406_n3215# 0
C61 a_746_939# gf180mcu_fd_sc_mcu7t5v0__mux2_1_0.S 0.03428f
C62 lut_0.REG[1] a_1490_n3008# 0.00461f
C63 reg_bank_5bit_0.gf180mcu_fd_sc_mcu7t5v0__latq_1_6.Q a_958_n7164# 0.00141f
C64 a_1062_n6630# a_1106_n7164# 0.00922f
C65 a_1102_n6946# a_1490_n7712# 0
C66 a_1310_n5596# VDDd 0.01299f
C67 a_958_n1396# CLK1 0
C68 reg_bank_5bit_0.gf180mcu_fd_sc_mcu7t5v0__latq_1_5.D a_570_n5595# 0.45943f
C69 a_1062_n358# a_1062_n1926# 0
C70 lut_0.REG[1] a_122_n4531# 0
C71 a_1106_n7164# VDDd 0.79039f
C72 lut_0.REG[3] a_1102_n2242# 0.01863f
C73 a_1310_n2460# CLK1 0.00841f
C74 gf180mcu_fd_sc_mcu7t5v0__mux2_1_0.S a_1490_n3008# 0
C75 a_1106_n892# D 0
C76 reg_bank_5bit_0.gf180mcu_fd_sc_mcu7t5v0__inv_1_0.ZN CLK2 0
C77 a_1462_1770# a_1090_1814# 0.10745f
C78 lut_0.LUT_OUT a_2390_1770# 0
C79 a_1106_n4028# CLK1 0.20682f
C80 gf180mcu_fd_sc_mcu7t5v0__mux2_1_0.S a_122_n4531# 0.01576f
C81 VDDd CLK2_BUFF 0.18038f
C82 a_570_n891# CLK1 0.04232f
C83 a_1106_n892# a_1102_n2242# 0.00361f
C84 lut_0.gf180mcu_fd_sc_mcu7t5v0__mux2_1_3.Z a_678_493# 0.21082f
C85 a_1062_n6630# a_1490_n7712# 0.00176f
C86 a_958_n5596# VDDd 0.00405f
C87 lut_0.gf180mcu_fd_sc_mcu7t5v0__mux2_1_3.Z a_2052_939# 0
C88 lut_0.REG[1] a_570_n2459# 0.0034f
C89 lut_0.gf180mcu_fd_sc_mcu7t5v0__mux2_1_3.Z OUT 0
C90 a_1350_n1396# CLK1 0.00181f
C91 a_210_n4975# a_570_n5595# 0.00202f
C92 reg_bank_5bit_0.gf180mcu_fd_sc_mcu7t5v0__latq_1_5.D a_122_n6099# 0.18741f
C93 gf180mcu_fd_sc_mcu7t5v0__mux2_1_0.I1 VDDd 0.54986f
C94 a_1490_n7712# VDDd 0.37853f
C95 lut_0.REG[1] a_1406_n3766# 0.00121f
C96 a_1106_n7164# a_958_n7668# 0
C97 lut_0.gf180mcu_fd_sc_mcu7t5v0__mux2_1_3.Z a_746_939# 0.1551f
C98 a_166_1479# lut_0.gf180mcu_fd_sc_mcu7t5v0__mux2_1_2.Z 0.09714f
C99 a_958_n2460# CLK1 0
C100 lut_0.REG[3] a_1062_n1926# 0.03741f
C101 gf180mcu_fd_sc_mcu7t5v0__mux2_1_0.S a_570_n2459# 0.0307f
C102 a_1106_n7164# CLK2 0.10074f
C103 lut_0.LUT_OUT a_2097_2182# 0.00123f
C104 a_1106_n5596# gf180mcu_fd_sc_mcu7t5v0__inv_1_0.ZN 0.00344f
C105 a_1490_n1440# D 0.01925f
C106 a_2390_1770# lut_0.REG[4] 0
C107 a_1490_n4576# CLK1 0.02719f
C108 gf180mcu_fd_sc_mcu7t5v0__mux2_1_0.S a_1406_n3766# 0.00126f
C109 a_1062_n3494# a_1102_n5378# 0
C110 lut_0.REG[2] a_1406_n1647# 0
C111 a_122_n1395# CLK1 0.02398f
C112 lut_0.gf180mcu_fd_sc_mcu7t5v0__mux2_1_2.Z a_210_n271# 0.00466f
C113 reg_bank_5bit_0.gf180mcu_fd_sc_mcu7t5v0__latq_1_3.D a_122_n2963# 0
C114 a_1490_n1440# a_1102_n2242# 0
C115 CLK2 CLK2_BUFF 0.02045f
C116 a_1106_n892# a_1062_n1926# 0.00854f
C117 lut_0.REG[2] a_1102_n3810# 0.01476f
C118 lut_0.gf180mcu_fd_sc_mcu7t5v0__mux2_1_2.Z a_210_110# 0.17656f
C119 a_166_1479# lut_0.REG[1] 0
C120 lut_0.REG[1] a_122_n2963# 0.00145f
C121 a_1062_n6630# a_570_n7163# 0.00418f
C122 a_1102_n6946# a_122_n7667# 0.00418f
C123 a_1310_n892# CLK1 0.00841f
C124 a_2382_2182# VDDd 0.00204f
C125 a_210_n4975# a_122_n6099# 0.00922f
C126 a_570_n7163# VDDd 0.32574f
C127 a_1106_n7164# a_1350_n7668# 0.01033f
C128 lut_0.gf180mcu_fd_sc_mcu7t5v0__mux2_1_2.Z a_990_1479# 0
C129 a_166_1479# gf180mcu_fd_sc_mcu7t5v0__mux2_1_0.S 0.0022f
C130 a_1106_n2460# CLK1 0.17245f
C131 gf180mcu_fd_sc_mcu7t5v0__mux2_1_0.S a_122_n2963# 0.02446f
C132 a_210_n271# reg_bank_5bit_0.gf180mcu_fd_sc_mcu7t5v0__latq_1_3.D 0.10616f
C133 a_534_2127# CLK_CLB 0.00462f
C134 a_1490_n6144# gf180mcu_fd_sc_mcu7t5v0__inv_1_0.ZN 0
C135 a_210_110# reg_bank_5bit_0.gf180mcu_fd_sc_mcu7t5v0__latq_1_3.D 0.00247f
C136 lut_0.REG[1] a_210_n271# 0.02138f
C137 lut_0.LUT_OUT a_1090_1814# 0.25009f
C138 a_1490_n7712# CLK2 0.03536f
C139 a_210_110# lut_0.REG[1] 0.50887f
C140 a_678_493# CLK1 0.00129f
C141 a_1062_n3494# a_1062_n5062# 0
C142 a_2097_2182# lut_0.REG[4] 0.00106f
C143 a_570_n4027# CLK1 0.04229f
C144 gf180mcu_fd_sc_mcu7t5v0__mux2_1_0.S a_922_n3766# 0.00311f
C145 a_1406_n630# CLK1 0.0024f
C146 gf180mcu_fd_sc_mcu7t5v0__mux2_1_0.S a_210_n271# 0.06069f
C147 a_1490_n1440# a_1062_n1926# 0.00173f
C148 gf180mcu_fd_sc_mcu7t5v0__mux2_1_0.S a_210_110# 0.04404f
C149 lut_0.REG[2] a_1062_n3494# 0.0366f
C150 IN[1] D 0.10054f
C151 gf180mcu_fd_sc_mcu7t5v0__mux2_1_0.I1 a_2444_1479# 0
C152 lut_0.REG[1] a_1406_n2198# 0.00112f
C153 a_1062_n6630# a_122_n7667# 0.00264f
C154 a_490_n6365# a_570_n7163# 0
C155 a_1102_n6946# a_1406_n6902# 0
C156 a_1434_2182# VDDd 0.00252f
C157 a_210_n4975# a_1406_n5334# 0.0013f
C158 reg_bank_5bit_0.gf180mcu_fd_sc_mcu7t5v0__latq_1_5.D a_922_n5334# 0.00587f
C159 lut_0.REG[2] D 0.03174f
C160 lut_0.REG[1] a_1406_n3215# 0
C161 a_570_n7163# a_958_n7668# 0
C162 a_990_1479# gf180mcu_fd_sc_mcu7t5v0__mux2_1_0.S 0
C163 a_122_n7667# VDDd 1.03736f
C164 a_1106_n7164# a_1310_n7164# 0.02084f
C165 a_1490_n3008# CLK1 0.02647f
C166 a_570_n7163# CLK2 0.21256f
C167 lut_0.LUT_OUT a_1462_1770# 0.02346f
C168 a_1490_n6144# a_1106_n5596# 0.39387f
C169 a_570_n5595# gf180mcu_fd_sc_mcu7t5v0__inv_1_0.ZN 0
C170 a_122_n4531# CLK1 0.02396f
C171 a_2390_1770# a_2200_939# 0.00196f
C172 lut_0.REG[2] a_1102_n2242# 0.01371f
C173 lut_0.gf180mcu_fd_sc_mcu7t5v0__mux2_1_3.Z a_166_1479# 0.55335f
C174 a_623_679# VDDd 0.0019f
C175 reg_bank_5bit_0.gf180mcu_fd_sc_mcu7t5v0__latq_1_3.D a_922_n2198# 0
C176 gf180mcu_fd_sc_mcu7t5v0__mux2_1_0.I1 a_2052_1479# 0
C177 a_1062_n6630# a_1406_n6902# 0.00251f
C178 a_490_n6365# a_122_n7667# 0.00176f
C179 a_1102_n6946# a_922_n6902# 0
C180 a_210_n4975# a_922_n5334# 0.02084f
C181 lut_0.gf180mcu_fd_sc_mcu7t5v0__mux2_1_3.Z a_210_n271# 0
C182 a_1106_n7164# a_958_n7164# 0.0013f
C183 a_1406_n6902# VDDd 0.00405f
C184 lut_0.gf180mcu_fd_sc_mcu7t5v0__mux2_1_3.Z a_210_110# 0.0022f
C185 a_570_n2459# CLK1 0.04231f
C186 gf180mcu_fd_sc_mcu7t5v0__mux2_1_0.S a_922_n2198# 0.00313f
C187 a_122_n7667# CLK2 0.52692f
C188 a_2134_493# a_2079_679# 0
C189 a_570_n5595# a_1106_n5596# 0.31543f
C190 a_122_n6099# gf180mcu_fd_sc_mcu7t5v0__inv_1_0.ZN 0
C191 a_1406_n3766# CLK1 0.0024f
C192 gf180mcu_fd_sc_mcu7t5v0__mux2_1_0.S a_922_n3229# 0.00142f
C193 a_490_n3229# a_490_n4797# 0
C194 lut_0.REG[2] a_1062_n1926# 0.0084f
C195 a_2097_2182# a_2200_939# 0.00821f
C196 lut_0.gf180mcu_fd_sc_mcu7t5v0__mux2_1_3.Z a_990_1479# 0
C197 a_1102_n6946# a_1406_n6351# 0
C198 lut_0.REG[1] a_1406_n1647# 0
C199 reg_bank_5bit_0.gf180mcu_fd_sc_mcu7t5v0__latq_1_5.D a_922_n4797# 0
C200 lut_0.REG[2] CLK1_BUFF 0.02158f
C201 a_210_n4975# a_1406_n4783# 0
C202 a_922_n6902# VDDd 0.01299f
C203 a_570_n7163# a_1310_n7164# 0
C204 lut_0.REG[1] a_1102_n3810# 0.03236f
C205 a_122_n2963# CLK1 0.02396f
C206 gf180mcu_fd_sc_mcu7t5v0__mux2_1_0.I1 OUT 0.08692f
C207 lut_0.LUT_OUT IN[0] 0.00287f
C208 a_122_n6099# a_1106_n5596# 0.06534f
C209 a_570_n5595# a_1490_n6144# 0.00578f
C210 a_1406_n6902# CLK2 0.00178f
C211 gf180mcu_fd_sc_mcu7t5v0__mux2_1_0.S a_1102_n3810# 0.01065f
C212 a_922_n3766# CLK1 0.00283f
C213 a_2097_2182# a_1620_1479# 0.0012f
C214 a_210_n271# CLK1 0.02524f
C215 a_534_2127# VDDd 1.10052f
C216 reg_bank_5bit_0.gf180mcu_fd_sc_mcu7t5v0__latq_1_3.D a_922_n1661# 0
C217 VDDd CLK_CLB 0.22424f
C218 a_210_n4975# a_922_n4797# 0.01033f
C219 reg_bank_5bit_0.gf180mcu_fd_sc_mcu7t5v0__latq_1_5.D a_1102_n5378# 0.00279f
C220 lut_0.REG[1] a_1062_n3494# 0.01146f
C221 a_570_n7163# a_958_n7164# 0
C222 gf180mcu_fd_sc_mcu7t5v0__mux2_1_0.S a_922_n1661# 0.00165f
C223 a_210_n3407# reg_bank_5bit_0.gf180mcu_fd_sc_mcu7t5v0__latq_1_8.D 0.1045f
C224 a_1406_n2198# CLK1 0.0024f
C225 a_922_n6902# CLK2 0.00192f
C226 reg_bank_5bit_0.gf180mcu_fd_sc_mcu7t5v0__latq_1_3.D D 0
C227 a_122_n6099# a_1490_n6144# 0.02784f
C228 lut_0.REG[1] D 0.03763f
C229 a_1406_n3215# CLK1 0
C230 gf180mcu_fd_sc_mcu7t5v0__mux2_1_0.S a_1062_n3494# 0.01082f
C231 a_534_2127# a_1666_110# 0
C232 a_922_1814# gf180mcu_fd_sc_mcu7t5v0__mux2_1_0.S 0
C233 a_1090_1814# a_1620_1479# 0
C234 gf180mcu_fd_sc_mcu7t5v0__mux2_1_0.S D 0.00116f
C235 a_2134_493# VDDd 0.49965f
C236 a_2079_679# VDDd 0.0019f
C237 lut_0.REG[1] a_1102_n2242# 0.01224f
C238 reg_bank_5bit_0.gf180mcu_fd_sc_mcu7t5v0__latq_1_0.D reg_bank_5bit_0.gf180mcu_fd_sc_mcu7t5v0__latq_1_8.D 0.0189f
C239 a_210_n4975# a_1102_n5378# 0.31543f
C240 reg_bank_5bit_0.gf180mcu_fd_sc_mcu7t5v0__latq_1_5.D a_1062_n5062# 0
C241 a_122_n7667# a_958_n7164# 0.00251f
C242 a_922_n2198# CLK1 0.00286f
C243 gf180mcu_fd_sc_mcu7t5v0__mux2_1_0.S a_1102_n2242# 0.00644f
C244 a_958_n2964# reg_bank_5bit_0.gf180mcu_fd_sc_mcu7t5v0__latq_1_8.D 0
C245 a_122_n6099# a_570_n5595# 0.71149f
C246 reg_bank_5bit_0.gf180mcu_fd_sc_mcu7t5v0__latq_1_8.D VDDd 0.59651f
C247 a_922_n3229# CLK1 0.00157f
C248 gf180mcu_fd_sc_mcu7t5v0__mux2_1_0.S a_490_n3229# 0.01355f
C249 lut_0.REG[4] a_2438_679# 0
C250 a_1666_110# a_2079_679# 0.00556f
C251 a_678_493# a_623_679# 0
C252 a_1666_110# a_2134_493# 0.03132f
C253 a_1462_1770# lut_0.REG[3] 0
C254 a_1062_n6630# a_1102_n6946# 0.71149f
C255 lut_0.REG[1] a_1062_n1926# 0.00593f
C256 a_2390_1770# IN[1] 0
C257 a_922_1814# lut_0.gf180mcu_fd_sc_mcu7t5v0__mux2_1_3.Z 0
C258 a_210_n1839# reg_bank_5bit_0.gf180mcu_fd_sc_mcu7t5v0__latq_1_8.D 0
C259 reg_bank_5bit_0.gf180mcu_fd_sc_mcu7t5v0__latq_1_0.D a_210_n3407# 0.00309f
C260 a_210_n4975# a_1062_n5062# 0.06534f
C261 reg_bank_5bit_0.gf180mcu_fd_sc_mcu7t5v0__latq_1_5.D a_490_n4797# 0.34448f
C262 a_1102_n6946# VDDd 0.32684f
C263 lut_0.gf180mcu_fd_sc_mcu7t5v0__mux2_1_3.Z D 0
C264 a_1406_n1647# CLK1 0
C265 gf180mcu_fd_sc_mcu7t5v0__mux2_1_0.S a_1062_n1926# 0.00708f
C266 a_922_n6365# CLK2 0
C267 a_210_n3407# VDDd 0.80138f
C268 lut_0.REG[2] a_210_n4975# 0.02081f
C269 lut_0.REG[1] CLK1_BUFF 0
C270 reg_bank_5bit_0.gf180mcu_fd_sc_mcu7t5v0__latq_1_8.D CLK2 0.22481f
C271 a_1102_n3810# CLK1 0.25677f
C272 lut_0.LUT_OUT a_2200_939# 0.00629f
C273 lut_0.LUT_OUT a_1062_n358# 0
C274 a_490_n93# reg_bank_5bit_0.gf180mcu_fd_sc_mcu7t5v0__latq_1_0.D 0
C275 reg_bank_5bit_0.gf180mcu_fd_sc_mcu7t5v0__latq_1_3.D a_490_n1661# 0.01791f
C276 gf180mcu_fd_sc_mcu7t5v0__mux2_1_0.S CLK1_BUFF 0
C277 a_490_n6365# a_1102_n6946# 0.00578f
C278 a_2097_2182# IN[1] 0
C279 lut_0.REG[4] a_1102_n674# 0.00128f
C280 reg_bank_5bit_0.gf180mcu_fd_sc_mcu7t5v0__latq_1_0.D a_958_n2964# 0.00238f
C281 a_210_n1839# a_210_n3407# 0.00103f
C282 reg_bank_5bit_0.gf180mcu_fd_sc_mcu7t5v0__latq_1_0.D VDDd 0.59775f
C283 a_210_n4975# a_490_n4797# 0.39387f
C284 a_1062_n6630# VDDd 1.02825f
C285 a_490_n93# VDDd 0.3833f
C286 gf180mcu_fd_sc_mcu7t5v0__mux2_1_0.S a_490_n1661# 0.01431f
C287 a_922_n1661# CLK1 0.00157f
C288 a_1102_n6946# CLK2 0.02072f
C289 a_1620_1479# IN[0] 0
C290 a_210_n3407# CLK2 0.09223f
C291 a_1062_n3494# CLK1 0.45929f
C292 reg_bank_5bit_0.gf180mcu_fd_sc_mcu7t5v0__latq_1_8.D a_1106_n4028# 0.0287f
C293 lut_0.LUT_OUT a_1620_1479# 0.73782f
C294 a_2200_939# lut_0.REG[4] 0.00604f
C295 a_210_n1839# reg_bank_5bit_0.gf180mcu_fd_sc_mcu7t5v0__latq_1_0.D 0.10387f
C296 D CLK1 0.16932f
C297 a_950_939# IN[0] 0
C298 lut_0.LUT_OUT lut_0.REG[3] 0.02199f
C299 a_490_n6365# a_1062_n6630# 0.02784f
C300 lut_0.REG[4] a_1062_n358# 0.01716f
C301 a_1090_1814# IN[1] 0
C302 a_210_n1839# VDDd 0.80138f
C303 a_590_190# VDDd 0
C304 a_490_n6365# VDDd 0.37945f
C305 a_1090_1814# lut_0.REG[2] 0
C306 a_1666_110# VDDd 0.74846f
C307 a_1102_n2242# CLK1 0.25639f
C308 a_598_939# VDDd 0.00522f
C309 reg_bank_5bit_0.gf180mcu_fd_sc_mcu7t5v0__latq_1_0.D CLK2 0.22781f
C310 a_534_2127# a_746_939# 0.01012f
C311 a_490_n93# CLK2 0
C312 a_1062_n6630# CLK2 0.11907f
C313 a_1102_n5378# a_1106_n5596# 0.00202f
C314 lut_0.REG[2] a_1350_n4532# 0.00304f
C315 a_1406_n79# VDDd 0
C316 a_958_n2964# CLK2 0
C317 a_490_n3229# CLK1 0.01006f
C318 VDDd CLK2 4.07611f
C319 gf180mcu_fd_sc_mcu7t5v0__inv_1_3.ZN VDDd 0.44862f
C320 a_958_n1396# reg_bank_5bit_0.gf180mcu_fd_sc_mcu7t5v0__latq_1_0.D 0
C321 a_982_679# IN[1] 0.00276f
C322 a_966_2182# gf180mcu_fd_sc_mcu7t5v0__mux2_1_0.S 0
C323 a_1462_1770# IN[1] 0
C324 lut_0.REG[2] a_982_679# 0.0016f
C325 lut_0.REG[3] lut_0.REG[4] 0.57957f
C326 a_210_110# a_623_679# 0.00556f
C327 gf180mcu_fd_sc_mcu7t5v0__mux2_1_0.S reg_bank_5bit_0.gf180mcu_fd_sc_mcu7t5v0__latq_1_5.D 0.00808f
C328 a_2134_493# OUT 0.00335f
C329 a_1062_n358# a_1102_n674# 0.71149f
C330 a_1462_1770# lut_0.REG[2] 0
C331 a_210_n1839# CLK2 0.09428f
C332 a_1062_n1926# CLK1 0.45821f
C333 a_1102_n5378# a_1490_n6144# 0
C334 a_490_n6365# CLK2 0.01407f
C335 a_1310_n2460# VDDd 0.01299f
C336 a_1062_n5062# a_1106_n5596# 0.00922f
C337 lut_0.REG[2] a_1310_n4028# 0.00126f
C338 a_570_n891# reg_bank_5bit_0.gf180mcu_fd_sc_mcu7t5v0__latq_1_0.D 0.0018f
C339 gf180mcu_fd_sc_mcu7t5v0__mux2_1_0.S Q 0.01503f
C340 reg_bank_5bit_0.gf180mcu_fd_sc_mcu7t5v0__latq_1_8.D a_570_n4027# 0.4593f
C341 a_490_n93# a_570_n891# 0
C342 lut_0.REG[4] a_1106_n892# 0.19087f
C343 a_1106_n4028# VDDd 0.79314f
C344 a_958_n7668# CLK2 0.00119f
C345 reg_bank_5bit_0.gf180mcu_fd_sc_mcu7t5v0__latq_1_5.D reg_bank_5bit_0.gf180mcu_fd_sc_mcu7t5v0__latq_1_6.Q 0.01889f
C346 lut_0.REG[2] a_1106_n5596# 0
C347 CLK1 CLK1_BUFF 0.00988f
C348 a_570_n891# VDDd 0.32787f
C349 a_2390_1770# gf180mcu_fd_sc_mcu7t5v0__mux2_1_0.S 0.00428f
C350 reg_bank_5bit_0.gf180mcu_fd_sc_mcu7t5v0__latq_1_0.D a_958_n2460# 0.00141f
C351 gf180mcu_fd_sc_mcu7t5v0__mux2_1_0.S a_210_n4975# 0.01605f
C352 a_958_n1396# CLK2 0
C353 a_490_n1661# CLK1 0.01014f
C354 a_966_2182# lut_0.gf180mcu_fd_sc_mcu7t5v0__mux2_1_3.Z 0
C355 lut_0.REG[3] a_1102_n674# 0.0018f
C356 a_958_n2460# VDDd 0.00405f
C357 a_1062_n5062# a_1490_n6144# 0.00176f
C358 a_570_n891# a_210_n1839# 0.00361f
C359 a_122_n1395# reg_bank_5bit_0.gf180mcu_fd_sc_mcu7t5v0__latq_1_0.D 0.00398f
C360 a_1310_n7164# VDDd 0.01299f
C361 a_1102_n674# a_922_n630# 0
C362 a_490_n93# a_122_n1395# 0.00176f
C363 a_210_n3407# a_570_n4027# 0.00202f
C364 reg_bank_5bit_0.gf180mcu_fd_sc_mcu7t5v0__latq_1_8.D a_122_n4531# 0.18733f
C365 lut_0.REG[4] a_1490_n1440# 0.37767f
C366 a_1490_n4576# VDDd 0.37945f
C367 a_534_2127# a_166_1479# 0
C368 a_1350_n7668# CLK2 0.0026f
C369 lut_0.REG[2] a_1490_n6144# 0.01924f
C370 a_210_n4975# reg_bank_5bit_0.gf180mcu_fd_sc_mcu7t5v0__latq_1_6.Q 0
C371 reg_bank_5bit_0.gf180mcu_fd_sc_mcu7t5v0__latq_1_5.D a_210_n6543# 0.0031f
C372 a_122_n1395# VDDd 1.03783f
C373 a_1106_n4028# CLK2 0
C374 a_1106_n4028# gf180mcu_fd_sc_mcu7t5v0__inv_1_3.ZN 0.00118f
C375 a_1620_1479# a_2200_939# 0.03132f
C376 a_1102_n674# a_1106_n892# 0.00202f
C377 a_166_1479# CLK_CLB 0.00599f
C378 IN[0] IN[1] 0.00176f
C379 lut_0.LUT_OUT IN[1] 0.03576f
C380 a_2097_2182# gf180mcu_fd_sc_mcu7t5v0__mux2_1_0.S 0.00506f
C381 a_1090_1814# lut_0.gf180mcu_fd_sc_mcu7t5v0__mux2_1_2.Z 0
C382 a_570_n891# CLK2 0.11226f
C383 a_1620_1479# a_1062_n358# 0
C384 reg_bank_5bit_0.gf180mcu_fd_sc_mcu7t5v0__latq_1_0.D a_1106_n2460# 0.02866f
C385 a_1310_n892# VDDd 0.01299f
C386 gf180mcu_fd_sc_mcu7t5v0__mux2_1_0.S a_958_n4532# 0
C387 lut_0.REG[2] IN[0] 0
C388 lut_0.LUT_OUT lut_0.REG[2] 0
C389 lut_0.LUT_OUT a_2404_939# 0
C390 a_678_493# a_490_n93# 0.01149f
C391 a_570_n2459# reg_bank_5bit_0.gf180mcu_fd_sc_mcu7t5v0__latq_1_8.D 0.00182f
C392 a_1106_n2460# a_958_n2964# 0
C393 lut_0.REG[3] a_1062_n358# 0.02802f
C394 a_1062_n5062# a_570_n5595# 0.00418f
C395 a_1102_n5378# a_122_n6099# 0.00418f
C396 a_1106_n2460# VDDd 0.80459f
C397 a_210_110# CLK_CLB 0.00178f
C398 a_958_n7164# VDDd 0.00405f
C399 a_570_n891# a_958_n1396# 0
C400 a_122_n1395# a_210_n1839# 0.00854f
C401 a_598_1479# IN[0] 0
C402 a_210_n3407# a_122_n4531# 0.00922f
C403 a_678_493# VDDd 0.41648f
C404 a_2052_939# VDDd 0.00486f
C405 a_1310_n7164# CLK2 0.00836f
C406 VDDd OUT 0.32926f
C407 a_570_n4027# VDDd 0.32689f
C408 a_210_n4975# a_210_n6543# 0.00103f
C409 reg_bank_5bit_0.gf180mcu_fd_sc_mcu7t5v0__latq_1_5.D a_958_n6100# 0.00241f
C410 lut_0.gf180mcu_fd_sc_mcu7t5v0__mux2_1_2.Z a_982_679# 0.00149f
C411 a_1406_n630# VDDd 0.00405f
C412 a_1062_n358# a_1106_n892# 0.00922f
C413 a_1102_n674# a_1490_n1440# 0
C414 a_1090_1814# gf180mcu_fd_sc_mcu7t5v0__mux2_1_0.S 0.0124f
C415 a_746_939# VDDd 0.7484f
C416 a_122_n1395# CLK2 0.48719f
C417 lut_0.REG[1] gf180mcu_fd_sc_mcu7t5v0__inv_1_0.ZN 0.02423f
C418 lut_0.REG[4] IN[1] 0.67115f
C419 a_2438_679# IN[1] 0.00397f
C420 CLK1_BUFF CLK2_BUFF 0.00189f
C421 a_1620_1479# lut_0.REG[3] 0
C422 reg_bank_5bit_0.gf180mcu_fd_sc_mcu7t5v0__latq_1_5.D CLK1 0.1303f
C423 gf180mcu_fd_sc_mcu7t5v0__mux2_1_0.S a_1350_n4532# 0
C424 a_2390_1770# a_2342_1814# 0
C425 lut_0.REG[4] a_2438_190# 0
C426 reg_bank_5bit_0.gf180mcu_fd_sc_mcu7t5v0__latq_1_0.D a_122_n4531# 0
C427 a_1666_110# a_2046_190# 0.00317f
C428 a_1106_n2460# a_1350_n2964# 0.01033f
C429 a_122_n2963# reg_bank_5bit_0.gf180mcu_fd_sc_mcu7t5v0__latq_1_8.D 0.00401f
C430 a_570_n2459# a_210_n3407# 0.00361f
C431 a_2404_939# lut_0.REG[4] 0
C432 lut_0.REG[2] lut_0.REG[4] 0.17037f
C433 a_678_493# a_1666_110# 0.00279f
C434 a_1102_n5378# a_1406_n5334# 0
C435 a_490_n4797# a_570_n5595# 0
C436 a_1062_n5062# a_122_n6099# 0.00264f
C437 gf180mcu_fd_sc_mcu7t5v0__mux2_1_0.S gf180mcu_fd_sc_mcu7t5v0__inv_1_0.ZN 0
C438 a_1490_n3008# VDDd 0.37945f
C439 a_1106_n892# a_958_n892# 0.0013f
C440 a_1106_n2460# CLK2 0
C441 reg_bank_5bit_0.gf180mcu_fd_sc_mcu7t5v0__latq_1_8.D a_922_n3766# 0.00589f
C442 a_210_n3407# a_1406_n3766# 0.0013f
C443 a_122_n4531# VDDd 1.03441f
C444 a_958_n7164# CLK2 0.00136f
C445 lut_0.REG[2] a_922_n93# 0.00115f
C446 gf180mcu_fd_sc_mcu7t5v0__mux2_1_0.S a_982_679# 0.00111f
C447 a_570_n4027# CLK2 0.11357f
C448 a_1490_n4576# a_1106_n4028# 0.39387f
C449 a_570_n4027# gf180mcu_fd_sc_mcu7t5v0__inv_1_3.ZN 0
C450 a_1062_n358# a_1490_n1440# 0.00176f
C451 a_746_939# a_598_939# 0.00106f
C452 lut_0.REG[3] a_1106_n892# 0.02074f
C453 a_1462_1770# gf180mcu_fd_sc_mcu7t5v0__mux2_1_0.S 0.00523f
C454 reg_bank_5bit_0.gf180mcu_fd_sc_mcu7t5v0__latq_1_0.D a_570_n2459# 0.45931f
C455 lut_0.REG[1] a_1106_n5596# 0.15099f
C456 gf180mcu_fd_sc_mcu7t5v0__mux2_1_0.S a_1310_n4028# 0.00489f
C457 a_122_n1395# a_570_n891# 0.71149f
C458 a_210_n4975# CLK1 0.05444f
C459 a_2097_2182# a_2342_1814# 0.00232f
C460 reg_bank_5bit_0.gf180mcu_fd_sc_mcu7t5v0__inv_1_0.ZN Q 0.34439f
C461 a_570_n2459# a_958_n2964# 0
C462 a_122_n2963# a_210_n3407# 0.00854f
C463 a_1106_n2460# a_1310_n2460# 0.02084f
C464 a_1102_n674# IN[1] 0.02554f
C465 a_570_n2459# VDDd 0.32689f
C466 a_1102_n5378# a_922_n5334# 0
C467 a_1062_n5062# a_1406_n5334# 0.00251f
C468 a_490_n4797# a_122_n6099# 0.00176f
C469 gf180mcu_fd_sc_mcu7t5v0__mux2_1_0.S a_1106_n5596# 0.02699f
C470 a_570_n891# a_1310_n892# 0
C471 a_2444_1479# OUT 0
C472 a_210_n3407# a_922_n3766# 0.02084f
C473 a_1106_n2460# a_1106_n4028# 0.00103f
C474 lut_0.REG[2] a_1102_n674# 0.02458f
C475 a_1406_n3766# VDDd 0.00405f
C476 a_122_n4531# CLK2 0.49877f
C477 a_570_n4027# a_1106_n4028# 0.31543f
C478 a_122_n4531# gf180mcu_fd_sc_mcu7t5v0__inv_1_3.ZN 0
C479 lut_0.gf180mcu_fd_sc_mcu7t5v0__mux2_1_2.Z IN[0] 0.5574f
C480 lut_0.LUT_OUT lut_0.gf180mcu_fd_sc_mcu7t5v0__mux2_1_2.Z 0.00792f
C481 a_678_493# a_570_n891# 0
C482 lut_0.REG[3] a_1490_n1440# 0.02264f
C483 a_210_n1839# a_570_n2459# 0.00202f
C484 reg_bank_5bit_0.gf180mcu_fd_sc_mcu7t5v0__latq_1_0.D a_122_n2963# 0.18735f
C485 lut_0.REG[1] a_1490_n6144# 0.35951f
C486 lut_0.gf180mcu_fd_sc_mcu7t5v0__mux2_1_3.Z a_982_679# 0
C487 a_2200_939# IN[1] 0.0175f
C488 a_958_n4532# CLK1 0
C489 gf180mcu_fd_sc_mcu7t5v0__mux2_1_0.S a_958_n4028# 0
C490 a_1106_n7164# Q 0
C491 a_1106_n2460# a_958_n2460# 0.0013f
C492 reg_bank_5bit_0.gf180mcu_fd_sc_mcu7t5v0__latq_1_0.D a_922_n3766# 0
C493 a_1462_1770# lut_0.gf180mcu_fd_sc_mcu7t5v0__mux2_1_3.Z 0
C494 a_166_1479# VDDd 0.50742f
C495 a_1062_n358# IN[1] 0.00773f
C496 reg_bank_5bit_0.gf180mcu_fd_sc_mcu7t5v0__latq_1_3.D IN[0] 0
C497 a_1102_n5378# a_1406_n4783# 0
C498 a_122_n2963# VDDd 1.03441f
C499 gf180mcu_fd_sc_mcu7t5v0__mux2_1_0.S a_1490_n6144# 0.03058f
C500 a_2200_939# a_2404_939# 0.00556f
C501 a_2052_1479# OUT 0
C502 lut_0.REG[1] IN[0] 0
C503 a_210_n271# reg_bank_5bit_0.gf180mcu_fd_sc_mcu7t5v0__latq_1_0.D 0
C504 a_1490_n1440# a_1106_n892# 0.39387f
C505 lut_0.LUT_OUT lut_0.REG[1] 0
C506 a_210_n271# a_490_n93# 0.39387f
C507 a_570_n2459# CLK2 0.11356f
C508 a_1490_n3008# a_1106_n4028# 0
C509 reg_bank_5bit_0.gf180mcu_fd_sc_mcu7t5v0__latq_1_8.D a_922_n3229# 0
C510 a_210_n3407# a_1406_n3215# 0
C511 lut_0.REG[2] a_1062_n358# 0.03156f
C512 a_922_n3766# VDDd 0.01299f
C513 a_210_110# a_490_n93# 0
C514 reg_bank_5bit_0.gf180mcu_fd_sc_mcu7t5v0__latq_1_5.D a_958_n5596# 0.00141f
C515 CLK2_BUFF Q 0.00783f
C516 a_210_n271# VDDd 0.81627f
C517 a_570_n4027# a_1490_n4576# 0.00578f
C518 a_122_n4531# a_1106_n4028# 0.06534f
C519 gf180mcu_fd_sc_mcu7t5v0__mux2_1_0.S IN[0] 0.16364f
C520 a_678_493# a_122_n1395# 0
C521 lut_0.LUT_OUT gf180mcu_fd_sc_mcu7t5v0__mux2_1_0.S 0.73739f
C522 a_210_110# VDDd 0.76109f
C523 a_534_2127# a_922_1814# 0.00393f
C524 a_210_n1839# a_122_n2963# 0.00922f
C525 lut_0.REG[1] a_570_n5595# 0
C526 a_1350_n4532# CLK1 0.00182f
C527 a_1620_1479# IN[1] 0.02308f
C528 a_166_1479# a_598_939# 0
C529 lut_0.REG[2] a_958_n892# 0
C530 a_570_n2459# a_1310_n2460# 0
C531 a_982_190# IN[1] 0
C532 a_1406_n2198# VDDd 0.00405f
C533 gf180mcu_fd_sc_mcu7t5v0__inv_1_0.ZN CLK1 0.00371f
C534 gf180mcu_fd_sc_mcu7t5v0__mux2_1_0.S a_570_n5595# 0.00755f
C535 a_1620_1479# a_2404_939# 0
C536 lut_0.REG[3] IN[1] 0.57069f
C537 a_210_n271# a_210_n1839# 0.00103f
C538 a_122_n2963# CLK2 0.49883f
C539 a_1490_n3008# a_1490_n4576# 0
C540 a_210_n3407# a_922_n3229# 0.01033f
C541 reg_bank_5bit_0.gf180mcu_fd_sc_mcu7t5v0__latq_1_8.D a_1102_n3810# 0.00285f
C542 lut_0.REG[2] a_982_190# 0
C543 lut_0.REG[3] a_2438_190# 0
C544 a_2390_1770# gf180mcu_fd_sc_mcu7t5v0__mux2_1_0.I1 0.30501f
C545 lut_0.REG[1] lut_0.REG[4] 0.0734f
C546 lut_0.REG[2] lut_0.REG[3] 1.14152f
C547 a_210_110# a_590_190# 0.00317f
C548 a_210_110# a_1666_110# 0
C549 lut_0.REG[2] a_1406_n4783# 0.00266f
C550 a_122_n4531# a_1490_n4576# 0.02784f
C551 a_2052_939# OUT 0
C552 reg_bank_5bit_0.gf180mcu_fd_sc_mcu7t5v0__latq_1_3.D a_922_n93# 0
C553 a_210_n271# a_1406_n79# 0
C554 a_570_n5595# reg_bank_5bit_0.gf180mcu_fd_sc_mcu7t5v0__latq_1_6.Q 0.00182f
C555 a_1106_n5596# a_958_n6100# 0
C556 lut_0.REG[2] a_922_n630# 0
C557 a_1106_n892# IN[1] 0
C558 a_210_n271# CLK2 0.03447f
C559 reg_bank_5bit_0.gf180mcu_fd_sc_mcu7t5v0__latq_1_0.D a_922_n2198# 0.00585f
C560 a_210_n1839# a_1406_n2198# 0.0013f
C561 lut_0.REG[1] a_122_n6099# 0
C562 a_210_110# CLK2 0.00254f
C563 gf180mcu_fd_sc_mcu7t5v0__mux2_1_0.S lut_0.REG[4] 0
C564 a_746_939# a_678_493# 0.0019f
C565 a_1310_n4028# CLK1 0.00843f
C566 a_746_939# OUT 0.00107f
C567 gf180mcu_fd_sc_mcu7t5v0__inv_1_0.ZN reg_bank_5bit_0.gf180mcu_fd_sc_mcu7t5v0__inv_1_0.ZN 0.01735f
C568 lut_0.REG[2] a_1106_n892# 0.00912f
C569 lut_0.gf180mcu_fd_sc_mcu7t5v0__mux2_1_3.Z IN[0] 0.7274f
C570 a_1462_1770# a_1414_1814# 0
C571 lut_0.LUT_OUT lut_0.gf180mcu_fd_sc_mcu7t5v0__mux2_1_3.Z 0.31817f
C572 gf180mcu_fd_sc_mcu7t5v0__mux2_1_0.S a_922_n93# 0.00276f
C573 reg_bank_5bit_0.gf180mcu_fd_sc_mcu7t5v0__latq_1_0.D a_922_n3229# 0
C574 a_570_n2459# a_958_n2460# 0
C575 a_1490_n3008# a_1106_n2460# 0.39387f
C576 a_922_n2198# VDDd 0.01299f
C577 a_1106_n5596# CLK1 0.17909f
C578 gf180mcu_fd_sc_mcu7t5v0__mux2_1_0.S a_122_n6099# 0.00784f
C579 reg_bank_5bit_0.gf180mcu_fd_sc_mcu7t5v0__latq_1_8.D a_1062_n3494# 0
C580 a_210_n3407# a_1102_n3810# 0.31543f
C581 a_2097_2182# gf180mcu_fd_sc_mcu7t5v0__mux2_1_0.I1 0.03439f
C582 a_570_n891# a_122_n2963# 0
C583 a_122_n4531# a_570_n4027# 0.71149f
C584 reg_bank_5bit_0.gf180mcu_fd_sc_mcu7t5v0__latq_1_3.D a_1102_n674# 0.00279f
C585 a_1106_n5596# a_1350_n6100# 0.01033f
C586 lut_0.REG[1] a_1102_n674# 0.02714f
C587 a_570_n5595# a_210_n6543# 0.00361f
C588 a_122_n6099# reg_bank_5bit_0.gf180mcu_fd_sc_mcu7t5v0__latq_1_6.Q 0.00401f
C589 reg_bank_5bit_0.gf180mcu_fd_sc_mcu7t5v0__latq_1_5.D a_122_n7667# 0
C590 a_1490_n1440# IN[1] 0
C591 a_210_n1839# a_922_n2198# 0.02084f
C592 lut_0.REG[1] a_1406_n5334# 0
C593 a_958_n4028# CLK1 0
C594 a_210_n271# a_570_n891# 0.00202f
C595 lut_0.REG[2] a_1490_n1440# 0.02055f
C596 a_122_n2963# a_958_n2460# 0.00251f
C597 a_570_n2459# a_1106_n2460# 0.31543f
C598 lut_0.LUT_OUT a_2342_1814# 0
C599 gf180mcu_fd_sc_mcu7t5v0__mux2_1_0.S a_1102_n674# 0.00625f
C600 a_1062_n5062# a_1102_n5378# 0.71149f
C601 a_1490_n6144# CLK1 0.0266f
C602 lut_0.gf180mcu_fd_sc_mcu7t5v0__mux2_1_2.Z a_1062_n358# 0
C603 gf180mcu_fd_sc_mcu7t5v0__mux2_1_0.S a_1406_n5334# 0
C604 lut_0.gf180mcu_fd_sc_mcu7t5v0__mux2_1_3.Z lut_0.REG[4] 0
C605 lut_0.gf180mcu_fd_sc_mcu7t5v0__mux2_1_3.Z a_2438_679# 0
C606 reg_bank_5bit_0.gf180mcu_fd_sc_mcu7t5v0__latq_1_8.D a_490_n3229# 0.34513f
C607 a_210_n3407# a_1062_n3494# 0.06534f
C608 a_1090_1814# gf180mcu_fd_sc_mcu7t5v0__mux2_1_0.I1 0.00246f
C609 a_2097_2182# a_2382_2182# 0.00277f
C610 a_1102_n3810# VDDd 0.32684f
C611 gf180mcu_fd_sc_mcu7t5v0__inv_1_0.ZN CLK2_BUFF 0.29124f
C612 lut_0.REG[2] a_1102_n5378# 0.40991f
C613 a_122_n1395# a_122_n2963# 0
C614 a_922_n3229# CLK2 0
C615 lut_0.LUT_OUT CLK1 0
C616 reg_bank_5bit_0.gf180mcu_fd_sc_mcu7t5v0__latq_1_3.D a_1062_n358# 0
C617 lut_0.REG[1] a_1062_n358# 0.00942f
C618 a_570_n5595# a_958_n6100# 0
C619 a_122_n6099# a_210_n6543# 0.00854f
C620 a_1106_n5596# a_1310_n5596# 0.02084f
C621 reg_bank_5bit_0.gf180mcu_fd_sc_mcu7t5v0__latq_1_0.D a_922_n1661# 0
C622 a_210_n1839# a_1406_n1647# 0
C623 a_210_n271# a_122_n1395# 0.00922f
C624 lut_0.gf180mcu_fd_sc_mcu7t5v0__mux2_1_2.Z a_1620_1479# 0
C625 gf180mcu_fd_sc_mcu7t5v0__mux2_1_0.S a_2200_939# 0.24855f
C626 a_1106_n5596# a_1106_n7164# 0.00103f
C627 a_210_110# a_122_n1395# 0
C628 a_570_n2459# a_1490_n3008# 0.00578f
C629 a_122_n2963# a_1106_n2460# 0.06534f
C630 lut_0.LUT_OUT a_1414_1814# 0.00113f
C631 gf180mcu_fd_sc_mcu7t5v0__mux2_1_0.S a_1062_n358# 0.01064f
C632 a_490_n4797# a_1102_n5378# 0.00578f
C633 a_570_n5595# CLK1 0.04227f
C634 a_166_1479# a_678_493# 0.00322f
C635 gf180mcu_fd_sc_mcu7t5v0__mux2_1_0.S a_922_n5334# 0.00155f
C636 reg_bank_5bit_0.gf180mcu_fd_sc_mcu7t5v0__latq_1_3.D a_958_n892# 0.00141f
C637 lut_0.gf180mcu_fd_sc_mcu7t5v0__mux2_1_2.Z a_950_939# 0.00179f
C638 a_570_n2459# a_122_n4531# 0
C639 a_210_n3407# a_490_n3229# 0.39387f
C640 a_1462_1770# gf180mcu_fd_sc_mcu7t5v0__mux2_1_0.I1 0.00279f
C641 a_1062_n3494# VDDd 1.02831f
C642 a_490_n93# D 0
C643 lut_0.gf180mcu_fd_sc_mcu7t5v0__mux2_1_2.Z a_922_n630# 0
C644 a_1106_n5596# CLK2_BUFF 0
C645 a_922_1814# VDDd 0
C646 lut_0.REG[2] a_1062_n5062# 0.14506f
C647 a_2438_190# IN[1] 0
C648 lut_0.REG[2] IN[1] 0.99763f
C649 a_2404_939# IN[1] 0
C650 a_1102_n3810# CLK2 0
C651 a_166_1479# a_746_939# 0.03132f
C652 reg_bank_5bit_0.gf180mcu_fd_sc_mcu7t5v0__latq_1_5.D a_922_n6902# 0
C653 a_1106_n5596# a_958_n5596# 0.0013f
C654 a_678_493# a_210_n271# 0
C655 VDDd D 0.20899f
C656 gf180mcu_fd_sc_mcu7t5v0__mux2_1_0.S a_958_n892# 0
C657 lut_0.REG[1] a_982_190# 0
C658 lut_0.REG[4] CLK1 0.40214f
C659 a_210_110# a_678_493# 0.03132f
C660 a_210_n1839# a_922_n1661# 0.01033f
C661 reg_bank_5bit_0.gf180mcu_fd_sc_mcu7t5v0__latq_1_0.D a_1102_n2242# 0.00273f
C662 lut_0.REG[1] lut_0.REG[3] 0.09878f
C663 gf180mcu_fd_sc_mcu7t5v0__mux2_1_0.S a_1620_1479# 0.35819f
C664 reg_bank_5bit_0.gf180mcu_fd_sc_mcu7t5v0__latq_1_3.D a_922_n630# 0.00587f
C665 a_210_n271# a_1406_n630# 0.0013f
C666 a_1490_n6144# a_1106_n7164# 0
C667 a_490_n1661# reg_bank_5bit_0.gf180mcu_fd_sc_mcu7t5v0__latq_1_8.D 0
C668 reg_bank_5bit_0.gf180mcu_fd_sc_mcu7t5v0__latq_1_0.D a_490_n3229# 0.0179f
C669 a_534_2127# a_966_2182# 0
C670 a_122_n2963# a_1490_n3008# 0.02784f
C671 a_122_n6099# CLK1 0.02393f
C672 a_1102_n2242# VDDd 0.32684f
C673 gf180mcu_fd_sc_mcu7t5v0__mux2_1_0.S a_1406_n4783# 0
C674 gf180mcu_fd_sc_mcu7t5v0__mux2_1_0.S lut_0.REG[3] 0.02693f
C675 a_490_n4797# a_1062_n5062# 0.02784f
C676 gf180mcu_fd_sc_mcu7t5v0__mux2_1_0.S a_950_939# 0
C677 reg_bank_5bit_0.gf180mcu_fd_sc_mcu7t5v0__latq_1_3.D a_1106_n892# 0.02853f
C678 lut_0.gf180mcu_fd_sc_mcu7t5v0__mux2_1_3.Z a_2200_939# 0
C679 a_922_n1661# CLK2 0
C680 lut_0.REG[1] a_1106_n892# 0.01634f
C681 a_122_n2963# a_122_n4531# 0
C682 a_1090_1814# a_1434_2182# 0.00275f
C683 a_490_n3229# VDDd 0.37945f
C684 gf180mcu_fd_sc_mcu7t5v0__mux2_1_0.S a_922_n630# 0.00405f
C685 lut_0.gf180mcu_fd_sc_mcu7t5v0__mux2_1_3.Z a_1062_n358# 0
C686 a_1062_n3494# CLK2 0.00216f
C687 a_1102_n3810# a_1106_n4028# 0.00202f
C688 a_746_939# a_990_1479# 0.00317f
C689 a_570_n5595# a_1310_n5596# 0
C690 gf180mcu_fd_sc_mcu7t5v0__mux2_1_0.S a_1106_n892# 0.00685f
C691 a_1406_n79# D 0.00213f
C692 a_210_n1839# a_1102_n2242# 0.31543f
C693 reg_bank_5bit_0.gf180mcu_fd_sc_mcu7t5v0__latq_1_0.D a_1062_n1926# 0
C694 a_1490_n6144# a_1490_n7712# 0
C695 a_534_2127# a_2390_1770# 0.02307f
C696 a_122_n2963# a_570_n2459# 0.71149f
C697 a_210_n1839# a_490_n3229# 0
C698 a_1102_n674# CLK1 0.22514f
C699 a_1062_n1926# VDDd 1.02831f
C700 gf180mcu_fd_sc_mcu7t5v0__mux2_1_0.S a_922_n4797# 0
C701 a_1406_n5334# CLK1 0.00241f
C702 lut_0.gf180mcu_fd_sc_mcu7t5v0__mux2_1_3.Z a_1620_1479# 0.00357f
C703 a_1102_n2242# CLK2 0
C704 lut_0.REG[1] a_1490_n1440# 0.00308f
C705 lut_0.LUT_OUT gf180mcu_fd_sc_mcu7t5v0__mux2_1_0.I1 0.04118f
C706 lut_0.gf180mcu_fd_sc_mcu7t5v0__mux2_1_3.Z lut_0.REG[3] 0.00334f
C707 a_490_n3229# CLK2 0.01365f
C708 a_1062_n3494# a_1106_n4028# 0.00922f
C709 a_1102_n3810# a_1490_n4576# 0
C710 lut_0.gf180mcu_fd_sc_mcu7t5v0__mux2_1_3.Z a_950_939# 0
C711 VDDd CLK1_BUFF 0.24563f
C712 a_570_n5595# a_958_n5596# 0
C713 gf180mcu_fd_sc_mcu7t5v0__mux2_1_0.S a_1490_n1440# 0
C714 reg_bank_5bit_0.gf180mcu_fd_sc_mcu7t5v0__latq_1_5.D a_922_n6365# 0
C715 reg_bank_5bit_0.gf180mcu_fd_sc_mcu7t5v0__latq_1_0.D a_490_n1661# 0.34399f
C716 a_210_n1839# a_1062_n1926# 0.06534f
C717 lut_0.REG[1] a_1102_n5378# 0.01704f
C718 a_490_n93# a_490_n1661# 0
C719 reg_bank_5bit_0.gf180mcu_fd_sc_mcu7t5v0__latq_1_8.D reg_bank_5bit_0.gf180mcu_fd_sc_mcu7t5v0__latq_1_5.D 0.01883f
C720 a_534_2127# a_2097_2182# 0.41635f
C721 a_1062_n358# CLK1 0.45042f
C722 a_922_n5334# CLK1 0.00285f
C723 a_490_n1661# VDDd 0.37945f
C724 gf180mcu_fd_sc_mcu7t5v0__mux2_1_0.S a_1102_n5378# 0.02337f
C725 a_2390_1770# a_2134_493# 0
C726 lut_0.gf180mcu_fd_sc_mcu7t5v0__mux2_1_2.Z IN[1] 0.02185f
C727 a_1062_n1926# CLK2 0.00216f
C728 a_1106_n2460# a_1102_n3810# 0.00361f
C729 a_1350_n1396# D 0
C730 lut_0.LUT_OUT a_2382_2182# 0
C731 a_166_1479# a_210_n271# 0
C732 gf180mcu_fd_sc_mcu7t5v0__mux2_1_0.I1 a_2438_679# 0
C733 lut_0.gf180mcu_fd_sc_mcu7t5v0__mux2_1_2.Z lut_0.REG[2] 0.05065f
C734 gf180mcu_fd_sc_mcu7t5v0__mux2_1_0.I1 lut_0.REG[4] 0.04248f
C735 a_166_1479# a_210_110# 0.0019f
C736 a_1062_n3494# a_1490_n4576# 0.00176f
C737 a_958_n892# CLK1 0
C738 a_122_n6099# a_958_n5596# 0.00251f
C739 reg_bank_5bit_0.gf180mcu_fd_sc_mcu7t5v0__latq_1_3.D IN[1] 0.00254f
C740 lut_0.REG[1] a_1062_n5062# 0.03182f
C741 a_210_n1839# a_490_n1661# 0.39387f
C742 gf180mcu_fd_sc_mcu7t5v0__inv_1_3.ZN CLK1_BUFF 0.29875f
C743 lut_0.REG[1] IN[1] 0.51261f
C744 a_1620_1479# CLK1 0
C745 a_210_n3407# reg_bank_5bit_0.gf180mcu_fd_sc_mcu7t5v0__latq_1_5.D 0
C746 reg_bank_5bit_0.gf180mcu_fd_sc_mcu7t5v0__latq_1_8.D a_210_n4975# 0.00309f
C747 lut_0.REG[2] reg_bank_5bit_0.gf180mcu_fd_sc_mcu7t5v0__latq_1_3.D 0.00384f
C748 a_210_110# a_210_n271# 0.03583f
C749 lut_0.gf180mcu_fd_sc_mcu7t5v0__mux2_1_3.Z a_1490_n1440# 0
C750 a_534_2127# a_1090_1814# 0.8399f
C751 lut_0.REG[1] lut_0.REG[2] 1.70194f
C752 a_1406_n4783# CLK1 0
C753 lut_0.REG[3] CLK1 0.46081f
C754 a_2097_2182# a_2134_493# 0
C755 gf180mcu_fd_sc_mcu7t5v0__mux2_1_0.S a_1062_n5062# 0.01087f
C756 gf180mcu_fd_sc_mcu7t5v0__mux2_1_0.S IN[1] 0.16124f
C757 a_490_n1661# CLK2 0.01436f
C758 a_1090_1814# CLK_CLB 0
C759 a_1106_n2460# a_1062_n3494# 0.00854f
C760 a_1490_n3008# a_1102_n3810# 0
C761 lut_0.LUT_OUT a_1434_2182# 0
C762 a_922_n630# CLK1 0.00285f
C763 a_1310_n892# D 0
C764 a_570_n891# a_1062_n1926# 0.00972f
C765 a_122_n1395# a_1102_n2242# 0.00972f
C766 gf180mcu_fd_sc_mcu7t5v0__mux2_1_0.S lut_0.REG[2] 0.28148f
C767 gf180mcu_fd_sc_mcu7t5v0__mux2_1_0.S a_2404_939# 0
C768 a_1062_n3494# a_570_n4027# 0.00418f
C769 a_1102_n3810# a_122_n4531# 0.00418f
C770 a_1106_n892# CLK1 0.1646f
C771 a_966_2182# VDDd 0
C772 a_1106_n4028# CLK1_BUFF 0.0036f
C773 reg_bank_5bit_0.gf180mcu_fd_sc_mcu7t5v0__latq_1_8.D a_958_n4532# 0.00239f
C774 a_210_n3407# a_210_n4975# 0.00103f
C775 reg_bank_5bit_0.gf180mcu_fd_sc_mcu7t5v0__latq_1_5.D VDDd 0.59712f
C776 a_570_n5595# a_122_n7667# 0
C777 a_534_2127# a_1462_1770# 1.16391f
C778 a_1102_n2242# a_1106_n2460# 0.00202f
C779 a_1406_n630# D 0
C780 gf180mcu_fd_sc_mcu7t5v0__mux2_1_0.S a_490_n4797# 0.0073f
C781 a_922_n4797# CLK1 0.00157f
C782 VDDd Q 0.2583f
C783 a_1462_1770# CLK_CLB 0
C784 a_1490_n3008# a_1062_n3494# 0.00173f
C785 a_570_n891# a_490_n1661# 0
C786 a_122_n1395# a_1062_n1926# 0.00352f
C787 a_490_n3229# a_570_n4027# 0
C788 a_1062_n3494# a_122_n4531# 0.00264f
C789 a_1102_n3810# a_1406_n3766# 0
C790 lut_0.gf180mcu_fd_sc_mcu7t5v0__mux2_1_3.Z IN[1] 0.35548f
C791 gf180mcu_fd_sc_mcu7t5v0__mux2_1_0.I1 a_2200_939# 0.53264f
C792 a_490_n4797# reg_bank_5bit_0.gf180mcu_fd_sc_mcu7t5v0__latq_1_6.Q 0
C793 reg_bank_5bit_0.gf180mcu_fd_sc_mcu7t5v0__latq_1_5.D a_490_n6365# 0.01792f
C794 a_1490_n1440# CLK1 0.02483f
C795 a_2390_1770# VDDd 0.51161f
C796 lut_0.gf180mcu_fd_sc_mcu7t5v0__mux2_1_3.Z lut_0.REG[2] 0.0512f
C797 a_1490_n4576# CLK1_BUFF 0.00113f
C798 lut_0.gf180mcu_fd_sc_mcu7t5v0__mux2_1_3.Z a_2404_939# 0
C799 a_122_n6099# a_122_n7667# 0
C800 a_210_n4975# VDDd 0.80138f
C801 a_1102_n2242# a_1490_n3008# 0
C802 a_1062_n1926# a_1106_n2460# 0.00922f
C803 reg_bank_5bit_0.gf180mcu_fd_sc_mcu7t5v0__latq_1_5.D CLK2 0.22502f
C804 a_1102_n5378# CLK1 0.25901f
C805 lut_0.gf180mcu_fd_sc_mcu7t5v0__mux2_1_3.Z a_598_1479# 0.00157f
C806 a_122_n2963# a_1102_n3810# 0.00972f
C807 a_570_n2459# a_1062_n3494# 0.00972f
C808 a_122_n1395# a_490_n1661# 0.00173f
C809 a_2342_1814# IN[1] 0
C810 a_490_n3229# a_122_n4531# 0.00176f
C811 a_1102_n3810# a_922_n3766# 0
C812 a_1062_n3494# a_1406_n3766# 0.00251f
C813 gf180mcu_fd_sc_mcu7t5v0__mux2_1_0.I1 a_1620_1479# 0.07734f
C814 a_2097_2182# VDDd 0.36451f
C815 a_210_n4975# a_490_n6365# 0
C816 lut_0.gf180mcu_fd_sc_mcu7t5v0__mux2_1_2.Z reg_bank_5bit_0.gf180mcu_fd_sc_mcu7t5v0__latq_1_3.D 0.01668f
C817 lut_0.gf180mcu_fd_sc_mcu7t5v0__mux2_1_2.Z lut_0.REG[1] 0.0503f
C818 a_534_2127# IN[0] 0.00595f
C819 a_1062_n1926# a_1490_n3008# 0.00176f
C820 a_534_2127# lut_0.LUT_OUT 0.33374f
C821 a_1062_n5062# CLK1 0.56646f
C822 a_210_n4975# CLK2 0.09232f
C823 IN[1] CLK1 0.06554f
C824 lut_0.gf180mcu_fd_sc_mcu7t5v0__mux2_1_2.Z gf180mcu_fd_sc_mcu7t5v0__mux2_1_0.S 0.23805f
C825 CLK_CLB IN[0] 0.01184f
C826 lut_0.LUT_OUT CLK_CLB 0.00838f
C827 a_122_n2963# a_1062_n3494# 0.00352f
C828 a_570_n2459# a_490_n3229# 0
C829 lut_0.REG[1] reg_bank_5bit_0.gf180mcu_fd_sc_mcu7t5v0__latq_1_3.D 0.00858f
C830 lut_0.REG[2] CLK1 0.83827f
C831 a_1102_n3810# a_1406_n3215# 0
C832 a_1090_1814# VDDd 0.39742f
C833 gf180mcu_fd_sc_mcu7t5v0__mux2_1_0.S reg_bank_5bit_0.gf180mcu_fd_sc_mcu7t5v0__latq_1_3.D 0.15383f
C834 gf180mcu_fd_sc_mcu7t5v0__mux2_1_0.S lut_0.REG[1] 1.91737f
C835 reg_bank_5bit_0.gf180mcu_fd_sc_mcu7t5v0__latq_1_8.D a_958_n4028# 0.00141f
C836 a_1106_n5596# a_1102_n6946# 0.00361f
C837 a_1102_n2242# a_122_n2963# 0.00418f
C838 a_210_n271# D 0.02326f
C839 a_1062_n1926# a_570_n2459# 0.00418f
C840 a_958_n4532# CLK2 0
C841 a_490_n4797# CLK1 0.0101f
C842 gf180mcu_fd_sc_mcu7t5v0__inv_1_0.ZN VDDd 0.47796f
C843 a_122_n2963# a_490_n3229# 0.00173f
C844 lut_0.REG[1] reg_bank_5bit_0.gf180mcu_fd_sc_mcu7t5v0__latq_1_6.Q 0.00135f
C845 a_1090_1814# a_1666_110# 0
C846 lut_0.gf180mcu_fd_sc_mcu7t5v0__mux2_1_3.Z lut_0.gf180mcu_fd_sc_mcu7t5v0__mux2_1_2.Z 0.26762f
C847 a_982_679# VDDd 0.00486f
C848 gf180mcu_fd_sc_mcu7t5v0__mux2_1_0.S reg_bank_5bit_0.gf180mcu_fd_sc_mcu7t5v0__latq_1_6.Q 0.00584f
C849 a_1462_1770# VDDd 0.18855f
C850 a_1490_n6144# a_1102_n6946# 0
C851 a_1310_n4028# VDDd 0.01299f
C852 a_1106_n5596# a_1062_n6630# 0.00854f
C853 a_1102_n2242# a_1406_n2198# 0
C854 a_490_n1661# a_570_n2459# 0
C855 a_1062_n1926# a_122_n2963# 0.00264f
C856 lut_0.gf180mcu_fd_sc_mcu7t5v0__mux2_1_3.Z lut_0.REG[1] 0.02489f
C857 a_1106_n4028# a_958_n4532# 0
C858 a_570_n4027# reg_bank_5bit_0.gf180mcu_fd_sc_mcu7t5v0__latq_1_5.D 0.00181f
C859 a_1106_n5596# VDDd 0.79314f
C860 a_2134_493# lut_0.REG[4] 0.48889f
C861 a_2134_493# a_2438_679# 0
C862 lut_0.REG[1] a_210_n6543# 0.02081f
C863 gf180mcu_fd_sc_mcu7t5v0__inv_1_0.ZN CLK2 0.29082f
C864 gf180mcu_fd_sc_mcu7t5v0__inv_1_3.ZN gf180mcu_fd_sc_mcu7t5v0__inv_1_0.ZN 0.01709f
C865 a_1462_1770# a_1666_110# 0
C866 lut_0.gf180mcu_fd_sc_mcu7t5v0__mux2_1_3.Z gf180mcu_fd_sc_mcu7t5v0__mux2_1_0.S 0.14547f
C867 gf180mcu_fd_sc_mcu7t5v0__mux2_1_0.S a_210_n6543# 0.01081f
C868 gf180mcu_fd_sc_mcu7t5v0__mux2_1_0.I1 IN[1] 0.0028f
C869 a_2390_1770# OUT 0
C870 a_958_n4028# VDDd 0.00405f
C871 a_1490_n6144# a_1062_n6630# 0.00173f
C872 a_1102_n2242# a_922_n2198# 0
C873 a_1062_n1926# a_1406_n2198# 0.00251f
C874 a_490_n1661# a_122_n2963# 0.00176f
C875 gf180mcu_fd_sc_mcu7t5v0__mux2_1_0.I1 a_2438_190# 0
C876 a_1106_n4028# a_1350_n4532# 0.01033f
C877 a_570_n4027# a_210_n4975# 0.00361f
C878 a_122_n4531# reg_bank_5bit_0.gf180mcu_fd_sc_mcu7t5v0__latq_1_5.D 0.00399f
C879 reg_bank_5bit_0.gf180mcu_fd_sc_mcu7t5v0__latq_1_8.D a_122_n6099# 0
C880 gf180mcu_fd_sc_mcu7t5v0__mux2_1_0.I1 a_2404_939# 0
C881 a_1490_n6144# VDDd 0.37945f
C882 a_210_n6543# reg_bank_5bit_0.gf180mcu_fd_sc_mcu7t5v0__latq_1_6.Q 0.10521f
C883 a_1106_n5596# CLK2 0.03513f
C884 a_210_n271# a_490_n1661# 0
C885 a_2342_1814# gf180mcu_fd_sc_mcu7t5v0__mux2_1_0.S 0
C886 a_1062_n3494# a_1102_n3810# 0.71149f
C887 a_1406_n1647# D 0
C888 VDDd IN[0] 0.61117f
C889 reg_bank_5bit_0.gf180mcu_fd_sc_mcu7t5v0__latq_1_3.D CLK1 0.12863f
C890 lut_0.LUT_OUT VDDd 0.60692f
C891 gf180mcu_fd_sc_mcu7t5v0__mux2_1_0.S a_958_n6100# 0
C892 lut_0.REG[1] CLK1 1.31646f
C893 a_2382_2182# IN[1] 0
C894 a_570_n5595# a_1062_n6630# 0.00972f
C895 a_122_n6099# a_1102_n6946# 0.00972f
C896 a_1102_n2242# a_1406_n1647# 0
C897 a_1106_n4028# a_1310_n4028# 0.02084f
C898 a_570_n4027# a_958_n4532# 0
C899 a_122_n4531# a_210_n4975# 0.00854f
C900 gf180mcu_fd_sc_mcu7t5v0__mux2_1_0.S CLK1 0.69394f
C901 a_570_n5595# VDDd 0.32689f
C902 a_534_2127# a_1620_1479# 0.00157f
C903 a_958_n6100# reg_bank_5bit_0.gf180mcu_fd_sc_mcu7t5v0__latq_1_6.Q 0
C904 lut_0.REG[1] a_1350_n6100# 0.00304f
C905 a_1106_n4028# a_1106_n5596# 0.00103f
C906 a_2200_939# a_2134_493# 0.00183f
C907 a_1490_n6144# CLK2 0
C908 a_598_939# IN[0] 0.00402f
C909 a_1414_1814# gf180mcu_fd_sc_mcu7t5v0__mux2_1_0.S 0
C910 a_534_2127# lut_0.REG[3] 0
C911 lut_0.LUT_OUT a_1666_110# 0.00283f
C912 a_2134_493# a_1062_n358# 0
C913 a_490_n3229# a_1102_n3810# 0.00578f
C914 gf180mcu_fd_sc_mcu7t5v0__mux2_1_0.S a_1350_n6100# 0
C915 reg_bank_5bit_0.gf180mcu_fd_sc_mcu7t5v0__latq_1_6.Q CLK1 0.00575f
C916 lut_0.REG[4] VDDd 0.87633f
C917 a_2438_679# VDDd 0.00486f
C918 a_570_n5595# a_490_n6365# 0
C919 a_122_n6099# a_1062_n6630# 0.00352f
C920 gf180mcu_fd_sc_mcu7t5v0__mux2_1_0.S reg_bank_5bit_0.gf180mcu_fd_sc_mcu7t5v0__inv_1_0.ZN 0.37102f
C921 a_1106_n4028# a_958_n4028# 0.0013f
C922 a_922_n93# VDDd 0
C923 reg_bank_5bit_0.gf180mcu_fd_sc_mcu7t5v0__latq_1_8.D a_922_n5334# 0
C924 a_122_n6099# VDDd 1.03441f
C925 a_1090_1814# a_746_939# 0
C926 a_1062_n1926# a_1102_n3810# 0
C927 lut_0.REG[1] a_1310_n5596# 0.00126f
C928 a_570_n5595# CLK2 0.11393f
C929 a_1620_1479# a_2134_493# 0.00331f
C930 a_623_679# IN[1] 0
C931 a_1490_n4576# a_1106_n5596# 0
C932 lut_0.LUT_OUT a_2444_1479# 0
C933 lut_0.REG[4] a_210_n1839# 0.02083f
C934 a_490_n3229# a_1062_n3494# 0.02784f
C935 lut_0.REG[1] a_1106_n7164# 0
C936 lut_0.REG[3] a_2079_679# 0
C937 a_1666_110# a_2438_679# 0.00106f
C938 a_678_493# a_982_679# 0
C939 a_210_n6543# CLK1 0.03729f
C940 lut_0.REG[3] a_2134_493# 0.07908f
C941 a_1666_110# lut_0.REG[4] 0.0083f
C942 gf180mcu_fd_sc_mcu7t5v0__mux2_1_0.S a_1310_n5596# 0.00292f
C943 a_490_n93# a_1102_n674# 0.00578f
C944 a_122_n6099# a_490_n6365# 0.00173f
C945 gf180mcu_fd_sc_mcu7t5v0__mux2_1_0.S a_1106_n7164# 0.15336f
C946 lut_0.REG[1] CLK2_BUFF 0.01603f
C947 a_1102_n674# VDDd 0.32723f
C948 a_570_n4027# a_1310_n4028# 0
C949 a_1406_n5334# VDDd 0.00405f
C950 a_1062_n1926# a_1062_n3494# 0
C951 a_122_n6099# CLK2 0.49904f
C952 a_1490_n4576# a_1490_n6144# 0
C953 gf180mcu_fd_sc_mcu7t5v0__mux2_1_0.S CLK2_BUFF 0
C954 reg_bank_5bit_0.gf180mcu_fd_sc_mcu7t5v0__latq_1_6.Q a_1106_n7164# 0.02521f
C955 lut_0.LUT_OUT a_2052_1479# 0
C956 lut_0.REG[1] a_1490_n7712# 0.01924f
C957 a_958_n6100# CLK1 0
C958 a_2444_1479# lut_0.REG[4] 0
C959 gf180mcu_fd_sc_mcu7t5v0__mux2_1_0.S a_958_n5596# 0
C960 gf180mcu_fd_sc_mcu7t5v0__mux2_1_0.I1 gf180mcu_fd_sc_mcu7t5v0__mux2_1_0.S 0.42487f
C961 a_490_n93# a_1062_n358# 0.02784f
C962 a_1666_110# a_1102_n674# 0.00185f
C963 a_2200_939# VDDd 0.75615f
C964 gf180mcu_fd_sc_mcu7t5v0__mux2_1_0.S a_1490_n7712# 0.31409f
C965 a_1062_n1926# a_1102_n2242# 0.71149f
C966 lut_0.REG[3] a_210_n3407# 0.02083f
C967 a_1062_n358# VDDd 1.0334f
C968 a_570_n4027# a_958_n4028# 0
C969 a_1102_n674# a_1406_n79# 0
C970 reg_bank_5bit_0.gf180mcu_fd_sc_mcu7t5v0__latq_1_8.D a_922_n4797# 0
C971 a_922_n5334# VDDd 0.01299f
C972 lut_0.REG[4] a_570_n891# 0
C973 lut_0.REG[4] a_1350_n1396# 0.00305f
C974 a_534_2127# IN[1] 0
C975 a_1350_n6100# CLK1 0.00184f
C976 a_958_n892# VDDd 0.00405f
C977 a_678_493# IN[0] 0.01983f
C978 lut_0.LUT_OUT a_678_493# 0
C979 lut_0.LUT_OUT a_2052_939# 0
C980 a_1666_110# a_1062_n358# 0.00384f
C981 a_1620_1479# VDDd 0.41369f
C982 lut_0.LUT_OUT OUT 0.00713f
C983 gf180mcu_fd_sc_mcu7t5v0__mux2_1_0.S a_570_n7163# 0.00477f
C984 a_490_n1661# a_1102_n2242# 0.00578f
C985 a_122_n4531# a_958_n4028# 0.00251f
C986 a_982_190# VDDd 0
C987 a_746_939# IN[0] 0.2347f
C988 lut_0.REG[4] a_122_n1395# 0
C989 gf180mcu_fd_sc_mcu7t5v0__mux2_1_0.I1 lut_0.gf180mcu_fd_sc_mcu7t5v0__mux2_1_3.Z 0
C990 lut_0.REG[3] VDDd 0.86181f
C991 a_950_939# VDDd 0.00201f
C992 lut_0.LUT_OUT a_746_939# 0.16147f
C993 a_490_n1661# a_490_n3229# 0
C994 lut_0.gf180mcu_fd_sc_mcu7t5v0__mux2_1_2.Z a_623_679# 0.00131f
C995 a_922_n630# VDDd 0.01299f
C996 reg_bank_5bit_0.gf180mcu_fd_sc_mcu7t5v0__latq_1_6.Q a_570_n7163# 0.45605f
C997 lut_0.REG[4] a_1310_n892# 0.00151f
C998 a_2079_679# IN[1] 0.00175f
C999 a_1310_n5596# CLK1 0.00844f
C1000 a_2134_493# IN[1] 0.34141f
C1001 a_1620_1479# a_1666_110# 0.00183f
C1002 a_2200_939# a_2444_1479# 0.00317f
C1003 a_1106_n892# VDDd 0.8046f
C1004 lut_0.REG[4] a_1106_n2460# 0.0029f
C1005 a_1434_2182# gf180mcu_fd_sc_mcu7t5v0__mux2_1_0.S 0
C1006 a_623_679# reg_bank_5bit_0.gf180mcu_fd_sc_mcu7t5v0__latq_1_3.D 0
C1007 lut_0.REG[4] a_2046_190# 0
C1008 a_1106_n7164# CLK1 0.02475f
C1009 a_2134_493# a_2438_190# 0.00166f
C1010 gf180mcu_fd_sc_mcu7t5v0__mux2_1_0.S a_122_n7667# 0.00686f
C1011 lut_0.REG[1] a_623_679# 0
C1012 a_210_110# a_982_679# 0.00106f
C1013 a_1666_110# lut_0.REG[3] 0.49173f
C1014 a_490_n1661# a_1062_n1926# 0.02784f
C1015 lut_0.REG[3] a_1350_n2964# 0.00306f
C1016 lut_0.REG[4] a_1406_n630# 0
C1017 gf180mcu_fd_sc_mcu7t5v0__mux2_1_0.I1 a_2342_1814# 0
C1018 gf180mcu_fd_sc_mcu7t5v0__mux2_1_0.S a_623_679# 0
C1019 a_570_n4027# a_122_n6099# 0
C1020 a_1102_n674# a_122_n1395# 0.00418f
C1021 a_1062_n358# a_570_n891# 0.00418f
C1022 reg_bank_5bit_0.gf180mcu_fd_sc_mcu7t5v0__latq_1_6.Q a_122_n7667# 0.18356f
C1023 a_210_n6543# a_570_n7163# 0.00202f
C1024 a_1666_110# a_1106_n892# 0
C1025 a_958_n5596# CLK1 0
C1026 a_2200_939# a_2052_1479# 0.00101f
C1027 a_1490_n1440# VDDd 0.37951f
C1028 a_1106_n7164# reg_bank_5bit_0.gf180mcu_fd_sc_mcu7t5v0__inv_1_0.ZN 0.00221f
C1029 lut_0.REG[4] a_1490_n3008# 0.01924f
C1030 a_1106_n892# CLK2 0
C1031 a_1062_n5062# a_1102_n6946# 0
C1032 a_1490_n7712# CLK1 0
C1033 gf180mcu_fd_sc_mcu7t5v0__mux2_1_0.S a_1406_n6902# 0
C1034 a_570_n891# a_958_n892# 0
C1035 a_490_n3229# reg_bank_5bit_0.gf180mcu_fd_sc_mcu7t5v0__latq_1_5.D 0
C1036 reg_bank_5bit_0.gf180mcu_fd_sc_mcu7t5v0__latq_1_8.D a_490_n4797# 0.01791f
C1037 lut_0.REG[3] a_1310_n2460# 0.00129f
C1038 a_1102_n5378# VDDd 0.32684f
C1039 gf180mcu_fd_sc_mcu7t5v0__mux2_1_0.I1 a_1414_1814# 0
C1040 a_678_493# a_1102_n674# 0.0012f
C1041 a_922_n4797# CLK2 0
C1042 lut_0.REG[3] a_1106_n4028# 0
C1043 a_1106_n892# a_958_n1396# 0
C1044 a_122_n4531# a_122_n6099# 0
C1045 lut_0.REG[2] a_210_n3407# 0
C1046 a_1102_n674# a_1406_n630# 0
C1047 a_1062_n358# a_122_n1395# 0.00264f
C1048 a_166_1479# IN[0] 0.33944f
C1049 reg_bank_5bit_0.gf180mcu_fd_sc_mcu7t5v0__latq_1_6.Q a_1406_n6902# 0
C1050 a_210_n6543# a_122_n7667# 0.00922f
C1051 lut_0.REG[3] a_570_n891# 0
C1052 a_534_2127# lut_0.gf180mcu_fd_sc_mcu7t5v0__mux2_1_2.Z 0
C1053 a_746_939# a_1102_n674# 0
C1054 lut_0.gf180mcu_fd_sc_mcu7t5v0__mux2_1_3.Z a_623_679# 0
C1055 a_1620_1479# a_2052_1479# 0.00166f
C1056 lut_0.gf180mcu_fd_sc_mcu7t5v0__mux2_1_2.Z CLK_CLB 0.00645f
C1057 gf180mcu_fd_sc_mcu7t5v0__mux2_1_0.S a_922_n6902# 0.00124f
C1058 a_1062_n5062# a_1062_n6630# 0
C1059 a_570_n7163# CLK1 0
C1060 a_490_n93# IN[1] 0
C1061 a_210_n271# IN[0] 0
C1062 a_2200_939# a_2052_939# 0.00106f
C1063 a_210_110# IN[0] 0.01187f
C1064 a_570_n891# a_1106_n892# 0.31543f
C1065 a_122_n1395# a_958_n892# 0.00251f
C1066 a_210_n3407# a_490_n4797# 0
C1067 a_534_2127# lut_0.REG[1] 0
C1068 a_2200_939# OUT 0.17254f
C1069 a_1062_n5062# VDDd 1.02831f
C1070 a_678_493# a_1062_n358# 0
C1071 lut_0.REG[2] a_490_n93# 0.00144f
C1072 VDDd IN[1] 1.34885f
C1073 a_1106_n892# a_1350_n1396# 0.01033f
C1074 a_1102_n5378# CLK2 0
C1075 lut_0.REG[3] a_1490_n4576# 0.01924f
C1076 a_1062_n358# a_1406_n630# 0.00251f
C1077 a_746_939# a_2200_939# 0
C1078 lut_0.REG[2] VDDd 0.84363f
C1079 reg_bank_5bit_0.gf180mcu_fd_sc_mcu7t5v0__latq_1_6.Q a_922_n6902# 0.00589f
C1080 a_210_n6543# a_1406_n6902# 0.0013f
C1081 lut_0.REG[3] a_122_n1395# 0
C1082 a_2404_939# VDDd 0.0019f
C1083 a_534_2127# gf180mcu_fd_sc_mcu7t5v0__mux2_1_0.S 0.01091f
C1084 lut_0.REG[1] a_1406_n6351# 0.00266f
C1085 a_746_939# a_1062_n358# 0
C1086 a_570_n7163# reg_bank_5bit_0.gf180mcu_fd_sc_mcu7t5v0__inv_1_0.ZN 0
C1087 a_1490_n7712# a_1106_n7164# 0.39387f
C1088 gf180mcu_fd_sc_mcu7t5v0__mux2_1_0.S CLK_CLB 0.00278f
C1089 a_1090_1814# a_922_1814# 0
C1090 gf180mcu_fd_sc_mcu7t5v0__mux2_1_0.S a_1406_n6351# 0
C1091 a_590_190# IN[1] 0
C1092 a_570_n891# a_1490_n1440# 0.00578f
C1093 a_122_n1395# a_1106_n892# 0.06534f
C1094 a_1620_1479# a_2052_939# 0
C1095 a_1666_110# IN[1] 0.38649f
C1096 lut_0.REG[3] a_1106_n2460# 0.15981f
C1097 a_1620_1479# OUT 0.00532f
C1098 lut_0.REG[2] a_210_n1839# 0
C1099 a_490_n4797# VDDd 0.37945f
C1100 lut_0.REG[3] a_2046_190# 0
C1101 a_1666_110# a_2438_190# 0.00101f
C1102 a_678_493# a_982_190# 0.00166f
C1103 lut_0.REG[2] a_1666_110# 0.01838f
C1104 a_1406_n79# IN[1] 0
C1105 a_678_493# lut_0.REG[3] 0
C1106 a_1062_n5062# CLK2 0.00326f
C1107 a_1106_n4028# a_1102_n5378# 0.00361f
C1108 a_1106_n892# a_1310_n892# 0.02084f
C1109 lut_0.REG[2] a_1350_n2964# 0
C1110 a_746_939# a_1620_1479# 0.00281f
C1111 a_210_n271# a_922_n93# 0.01033f
C1112 a_210_n6543# a_922_n6902# 0.02084f
C1113 lut_0.REG[2] a_1406_n79# 0
C1114 a_1106_n892# a_1106_n2460# 0.00103f
C1115 gf180mcu_fd_sc_mcu7t5v0__mux2_1_0.S a_2079_679# 0
C1116 lut_0.REG[2] gf180mcu_fd_sc_mcu7t5v0__inv_1_3.ZN 0.016f
C1117 gf180mcu_fd_sc_mcu7t5v0__mux2_1_0.S a_2134_493# 0.02297f
C1118 a_746_939# a_950_939# 0.00556f
C1119 a_122_n7667# reg_bank_5bit_0.gf180mcu_fd_sc_mcu7t5v0__inv_1_0.ZN 0
C1120 a_570_n7163# a_1106_n7164# 0.31543f
C1121 a_534_2127# lut_0.gf180mcu_fd_sc_mcu7t5v0__mux2_1_3.Z 0.01337f
C1122 a_1406_n6902# CLK1 0
C1123 a_490_n4797# a_490_n6365# 0
C1124 gf180mcu_fd_sc_mcu7t5v0__mux2_1_0.S a_922_n6365# 0
C1125 a_122_n1395# a_1490_n1440# 0.02784f
C1126 a_2444_1479# IN[1] 0
C1127 lut_0.REG[3] a_1490_n3008# 0.36149f
C1128 gf180mcu_fd_sc_mcu7t5v0__mux2_1_0.S reg_bank_5bit_0.gf180mcu_fd_sc_mcu7t5v0__latq_1_8.D 0.0535f
C1129 lut_0.gf180mcu_fd_sc_mcu7t5v0__mux2_1_3.Z CLK_CLB 0.01013f
C1130 a_490_n4797# CLK2 0.01366f
C1131 a_1106_n4028# a_1062_n5062# 0.00854f
C1132 a_1490_n4576# a_1102_n5378# 0
C1133 lut_0.REG[2] a_1310_n2460# 0.00142f
C1134 a_210_n271# a_1102_n674# 0.31543f
C1135 reg_bank_5bit_0.gf180mcu_fd_sc_mcu7t5v0__latq_1_6.Q a_922_n6365# 0
C1136 a_210_n6543# a_1406_n6351# 0
C1137 a_2382_2182# gf180mcu_fd_sc_mcu7t5v0__mux2_1_0.I1 0
C1138 lut_0.REG[1] a_1102_n6946# 0.4082f
C1139 a_570_n891# IN[1] 0
C1140 a_1490_n1440# a_1106_n2460# 0
C1141 lut_0.REG[2] a_1106_n4028# 0.14964f
C1142 lut_0.REG[1] a_210_n3407# 0.00324f
C1143 a_122_n7667# a_1106_n7164# 0.06534f
C1144 a_570_n7163# a_1490_n7712# 0.00578f
C1145 lut_0.REG[2] a_570_n891# 0
C1146 a_534_2127# a_2342_1814# 0
C1147 a_1350_n1396# IN[1] 0
C1148 gf180mcu_fd_sc_mcu7t5v0__mux2_1_0.S a_1102_n6946# 0.02397f
C1149 a_922_n6902# CLK1 0
C1150 lut_0.gf180mcu_fd_sc_mcu7t5v0__mux2_1_2.Z a_490_n93# 0.0022f
C1151 lut_0.gf180mcu_fd_sc_mcu7t5v0__mux2_1_3.Z a_2134_493# 0
C1152 lut_0.gf180mcu_fd_sc_mcu7t5v0__mux2_1_3.Z a_2079_679# 0
C1153 a_2052_1479# IN[1] 0
C1154 lut_0.REG[3] a_570_n2459# 0
C1155 gf180mcu_fd_sc_mcu7t5v0__mux2_1_0.S a_210_n3407# 0.043f
C1156 lut_0.REG[2] a_1350_n1396# 0
C1157 lut_0.gf180mcu_fd_sc_mcu7t5v0__mux2_1_2.Z VDDd 0.87268f
C1158 a_1490_n4576# a_1062_n5062# 0.00173f
C1159 reg_bank_5bit_0.gf180mcu_fd_sc_mcu7t5v0__latq_1_3.D reg_bank_5bit_0.gf180mcu_fd_sc_mcu7t5v0__latq_1_0.D 0.01881f
C1160 reg_bank_5bit_0.gf180mcu_fd_sc_mcu7t5v0__latq_1_3.D a_490_n93# 0.34555f
C1161 a_210_n271# a_1062_n358# 0.06534f
C1162 a_210_n6543# a_922_n6365# 0.01033f
C1163 reg_bank_5bit_0.gf180mcu_fd_sc_mcu7t5v0__latq_1_6.Q a_1102_n6946# 0.00324f
C1164 a_1434_2182# gf180mcu_fd_sc_mcu7t5v0__mux2_1_0.I1 0
C1165 a_122_n1395# IN[1] 0
C1166 lut_0.REG[1] a_490_n93# 0.00357f
C1167 lut_0.REG[1] a_1062_n6630# 0.14509f
C1168 a_1490_n1440# a_1490_n3008# 0
C1169 a_210_n4975# reg_bank_5bit_0.gf180mcu_fd_sc_mcu7t5v0__latq_1_5.D 0.10419f
C1170 lut_0.REG[2] a_1490_n4576# 0.35678f
C1171 a_122_n7667# a_1490_n7712# 0.02784f
C1172 lut_0.REG[4] a_1406_n1647# 0.00268f
C1173 reg_bank_5bit_0.gf180mcu_fd_sc_mcu7t5v0__latq_1_3.D VDDd 0.65984f
C1174 a_922_1814# IN[0] 0
C1175 lut_0.REG[1] VDDd 0.85262f
C1176 gf180mcu_fd_sc_mcu7t5v0__mux2_1_0.S reg_bank_5bit_0.gf180mcu_fd_sc_mcu7t5v0__latq_1_0.D 0.12673f
C1177 lut_0.REG[2] a_122_n1395# 0
C1178 lut_0.LUT_OUT a_922_1814# 0
C1179 a_534_2127# a_1414_1814# 0.00306f
C1180 a_1310_n892# IN[1] 0
C1181 a_1406_n6351# CLK1 0
C1182 gf180mcu_fd_sc_mcu7t5v0__mux2_1_0.S a_490_n93# 0.03394f
C1183 gf180mcu_fd_sc_mcu7t5v0__mux2_1_0.S a_1062_n6630# 0.0242f
C1184 lut_0.gf180mcu_fd_sc_mcu7t5v0__mux2_1_2.Z a_590_190# 0
C1185 lut_0.REG[3] a_122_n2963# 0
C1186 lut_0.gf180mcu_fd_sc_mcu7t5v0__mux2_1_2.Z a_598_939# 0.00206f
C1187 a_166_1479# a_950_939# 0
C1188 gf180mcu_fd_sc_mcu7t5v0__mux2_1_0.S a_958_n2964# 0
C1189 lut_0.LUT_OUT D 0
C1190 lut_0.REG[2] a_1310_n892# 0.00142f
C1191 gf180mcu_fd_sc_mcu7t5v0__mux2_1_0.S VDDd 1.67882f
C1192 a_2046_190# IN[1] 0
C1193 a_678_493# IN[1] 0.42044f
C1194 a_122_n4531# a_1102_n5378# 0.00972f
C1195 a_570_n4027# a_1062_n5062# 0.00972f
C1196 a_1310_n4028# CLK1_BUFF 0
C1197 a_2052_939# IN[1] 0
C1198 lut_0.gf180mcu_fd_sc_mcu7t5v0__mux2_1_2.Z CLK2 0.00202f
C1199 lut_0.REG[2] a_1106_n2460# 0.02398f
C1200 reg_bank_5bit_0.gf180mcu_fd_sc_mcu7t5v0__latq_1_3.D a_210_n1839# 0.00309f
C1201 reg_bank_5bit_0.gf180mcu_fd_sc_mcu7t5v0__latq_1_6.Q a_1062_n6630# 0.00249f
C1202 a_210_n6543# a_1102_n6946# 0.31543f
C1203 lut_0.REG[1] a_210_n1839# 0.00475f
C1204 a_590_190# reg_bank_5bit_0.gf180mcu_fd_sc_mcu7t5v0__latq_1_3.D 0
C1205 lut_0.REG[1] a_590_190# 0
C1206 a_210_110# a_982_190# 0.00101f
C1207 a_1406_n630# IN[1] 0
C1208 a_678_493# lut_0.REG[2] 0.48473f
C1209 lut_0.REG[1] a_1666_110# 0.00119f
C1210 a_958_n4532# reg_bank_5bit_0.gf180mcu_fd_sc_mcu7t5v0__latq_1_5.D 0
C1211 lut_0.REG[2] a_570_n4027# 0
C1212 a_2404_939# OUT 0
C1213 a_210_n271# a_922_n630# 0.02084f
C1214 reg_bank_5bit_0.gf180mcu_fd_sc_mcu7t5v0__latq_1_6.Q VDDd 0.59203f
C1215 lut_0.REG[1] a_1350_n2964# 0.00117f
C1216 a_746_939# IN[1] 0.01391f
C1217 a_122_n7667# a_570_n7163# 0.71149f
C1218 lut_0.REG[2] a_1406_n630# 0
C1219 gf180mcu_fd_sc_mcu7t5v0__mux2_1_0.S a_210_n1839# 0.04066f
C1220 lut_0.REG[1] a_1406_n79# 0
C1221 a_922_n6365# CLK1 0.00157f
C1222 reg_bank_5bit_0.gf180mcu_fd_sc_mcu7t5v0__latq_1_3.D CLK2 0.07458f
C1223 gf180mcu_fd_sc_mcu7t5v0__mux2_1_0.S a_490_n6365# 0.00534f
C1224 gf180mcu_fd_sc_mcu7t5v0__mux2_1_0.S a_1666_110# 0.0192f
C1225 lut_0.REG[1] CLK2 0.18987f
C1226 lut_0.REG[1] gf180mcu_fd_sc_mcu7t5v0__inv_1_3.ZN 0
C1227 a_746_939# lut_0.REG[2] 0
C1228 gf180mcu_fd_sc_mcu7t5v0__mux2_1_0.S a_598_939# 0
C1229 lut_0.REG[3] a_1406_n2198# 0
C1230 reg_bank_5bit_0.gf180mcu_fd_sc_mcu7t5v0__latq_1_8.D CLK1 0.13033f
C1231 a_1090_1814# a_966_2182# 0
C1232 a_2097_2182# a_2390_1770# 0.49319f
C1233 lut_0.REG[4] D 0.00322f
C1234 lut_0.REG[3] a_1406_n3215# 0.00268f
C1235 gf180mcu_fd_sc_mcu7t5v0__mux2_1_0.S CLK2 0.28357f
C1236 a_122_n4531# a_1062_n5062# 0.00352f
C1237 a_570_n4027# a_490_n4797# 0
C1238 lut_0.REG[2] a_1490_n3008# 0.03113f
C1239 reg_bank_5bit_0.gf180mcu_fd_sc_mcu7t5v0__latq_1_3.D a_958_n1396# 0.00236f
C1240 a_746_939# a_598_1479# 0.00101f
C1241 a_210_n6543# a_1062_n6630# 0.06534f
C1242 reg_bank_5bit_0.gf180mcu_fd_sc_mcu7t5v0__latq_1_6.Q a_490_n6365# 0.34513f
C1243 lut_0.gf180mcu_fd_sc_mcu7t5v0__mux2_1_3.Z VDDd 0.58571f
C1244 lut_0.REG[2] a_122_n4531# 0
C1245 a_210_n6543# VDDd 0.80138f
C1246 lut_0.REG[1] a_1310_n2460# 0.00404f
C1247 reg_bank_5bit_0.gf180mcu_fd_sc_mcu7t5v0__latq_1_6.Q a_958_n7668# 0.00239f
C1248 lut_0.REG[4] a_1102_n2242# 0.40928f
C1249 gf180mcu_fd_sc_mcu7t5v0__mux2_1_0.S a_958_n1396# 0
C1250 reg_bank_5bit_0.gf180mcu_fd_sc_mcu7t5v0__latq_1_6.Q CLK2 0.4565f
C1251 a_1102_n6946# CLK1 0.25215f
C1252 lut_0.REG[1] a_1106_n4028# 0.0214f
C1253 reg_bank_5bit_0.gf180mcu_fd_sc_mcu7t5v0__latq_1_3.D a_570_n891# 0.45916f
C1254 a_210_n3407# CLK1 0.05441f
C1255 lut_0.REG[1] a_570_n891# 0.00452f
C1256 a_534_2127# gf180mcu_fd_sc_mcu7t5v0__mux2_1_0.I1 0.0043f
C1257 gf180mcu_fd_sc_mcu7t5v0__mux2_1_0.S a_1106_n4028# 0.02812f
C1258 lut_0.gf180mcu_fd_sc_mcu7t5v0__mux2_1_3.Z a_1666_110# 0.13645f
C1259 a_122_n4531# a_490_n4797# 0.00173f
C1260 lut_0.REG[2] a_570_n2459# 0
C1261 a_210_n6543# a_490_n6365# 0.39387f
C1262 lut_0.REG[1] a_1350_n1396# 0.00105f
C1263 gf180mcu_fd_sc_mcu7t5v0__mux2_1_0.S a_570_n891# 0.03287f
C1264 lut_0.gf180mcu_fd_sc_mcu7t5v0__mux2_1_2.Z a_122_n1395# 0
C1265 a_1102_n674# D 0.4113f
C1266 Q VSSd 0.27434f
C1267 CLK2_BUFF VSSd 0.3392f
C1268 CLK1_BUFF VSSd 0.34724f
C1269 CLK2 VSSd -3.72255f
C1270 CLK1 VSSd -6.57845f
C1271 D VSSd 0.5244f
C1272 IN[1] VSSd 1.52361f
C1273 OUT VSSd 0.40198f
C1274 IN[0] VSSd 0.69428f
C1275 CLK_CLB VSSd 0.36624f
C1276 VDDd VSSd 75.8993f
C1277 a_958_n7668# VSSd 0.00195f
C1278 a_1350_n7668# VSSd 0.00695f
C1279 reg_bank_5bit_0.gf180mcu_fd_sc_mcu7t5v0__inv_1_0.ZN VSSd 0.66506f
C1280 a_1106_n7164# VSSd 1.19168f
C1281 a_1490_n7712# VSSd 0.44258f
C1282 a_570_n7163# VSSd 0.49731f
C1283 a_122_n7667# VSSd 1.02921f
C1284 a_1406_n6351# VSSd 0.00195f
C1285 a_922_n6365# VSSd 0.00695f
C1286 a_1102_n6946# VSSd 0.48662f
C1287 a_1062_n6630# VSSd 1.00499f
C1288 a_490_n6365# VSSd 0.43016f
C1289 reg_bank_5bit_0.gf180mcu_fd_sc_mcu7t5v0__latq_1_6.Q VSSd 0.69619f
C1290 a_210_n6543# VSSd 1.17576f
C1291 a_958_n6100# VSSd 0.00195f
C1292 a_1350_n6100# VSSd 0.00695f
C1293 gf180mcu_fd_sc_mcu7t5v0__inv_1_0.ZN VSSd 0.58093f
C1294 a_1106_n5596# VSSd 1.16005f
C1295 a_1490_n6144# VSSd 0.43001f
C1296 a_570_n5595# VSSd 0.48651f
C1297 a_122_n6099# VSSd 1.00506f
C1298 a_1406_n4783# VSSd 0.00195f
C1299 a_922_n4797# VSSd 0.00695f
C1300 a_1102_n5378# VSSd 0.4869f
C1301 a_1062_n5062# VSSd 1.00344f
C1302 a_490_n4797# VSSd 0.42966f
C1303 reg_bank_5bit_0.gf180mcu_fd_sc_mcu7t5v0__latq_1_5.D VSSd 0.69726f
C1304 a_210_n4975# VSSd 1.17442f
C1305 a_958_n4532# VSSd 0.00195f
C1306 a_1350_n4532# VSSd 0.00695f
C1307 gf180mcu_fd_sc_mcu7t5v0__inv_1_3.ZN VSSd 0.65652f
C1308 a_1106_n4028# VSSd 1.15902f
C1309 a_1490_n4576# VSSd 0.42974f
C1310 a_570_n4027# VSSd 0.48651f
C1311 a_122_n4531# VSSd 1.00506f
C1312 a_1406_n3215# VSSd 0.00195f
C1313 a_922_n3229# VSSd 0.00695f
C1314 a_1102_n3810# VSSd 0.48719f
C1315 a_1062_n3494# VSSd 1.00542f
C1316 a_490_n3229# VSSd 0.42966f
C1317 reg_bank_5bit_0.gf180mcu_fd_sc_mcu7t5v0__latq_1_8.D VSSd 0.69684f
C1318 a_210_n3407# VSSd 1.17442f
C1319 a_958_n2964# VSSd 0.00195f
C1320 a_1350_n2964# VSSd 0.00695f
C1321 a_1106_n2460# VSSd 1.17443f
C1322 a_1490_n3008# VSSd 0.43014f
C1323 a_570_n2459# VSSd 0.48651f
C1324 a_122_n2963# VSSd 1.00506f
C1325 a_1406_n1647# VSSd 0.00195f
C1326 a_922_n1661# VSSd 0.00695f
C1327 a_1102_n2242# VSSd 0.48719f
C1328 a_1062_n1926# VSSd 1.00542f
C1329 a_490_n1661# VSSd 0.42966f
C1330 reg_bank_5bit_0.gf180mcu_fd_sc_mcu7t5v0__latq_1_0.D VSSd 0.69625f
C1331 a_210_n1839# VSSd 1.17442f
C1332 a_958_n1396# VSSd 0.00195f
C1333 a_1350_n1396# VSSd 0.00695f
C1334 a_1106_n892# VSSd 1.17478f
C1335 a_1490_n1440# VSSd 0.43069f
C1336 a_570_n891# VSSd 0.48651f
C1337 a_122_n1395# VSSd 1.00518f
C1338 a_1406_n79# VSSd 0.00195f
C1339 a_922_n93# VSSd 0.00695f
C1340 a_1102_n674# VSSd 0.484f
C1341 a_1062_n358# VSSd 1.00496f
C1342 a_490_n93# VSSd 0.4314f
C1343 reg_bank_5bit_0.gf180mcu_fd_sc_mcu7t5v0__latq_1_3.D VSSd 0.68918f
C1344 a_210_n271# VSSd 1.1652f
C1345 a_2438_190# VSSd 0.00241f
C1346 a_2046_190# VSSd 0
C1347 a_982_190# VSSd 0.0022f
C1348 a_590_190# VSSd 0
C1349 a_2438_679# VSSd 0
C1350 a_2079_679# VSSd 0
C1351 lut_0.REG[4] VSSd 1.68491f
C1352 a_2134_493# VSSd 0.70802f
C1353 lut_0.REG[3] VSSd 1.47506f
C1354 a_1666_110# VSSd 0.83084f
C1355 lut_0.REG[2] VSSd 1.39466f
C1356 a_678_493# VSSd 0.63521f
C1357 lut_0.REG[1] VSSd 1.48737f
C1358 a_210_110# VSSd 0.8269f
C1359 a_2404_939# VSSd 0
C1360 a_2052_939# VSSd 0
C1361 a_2444_1479# VSSd 0
C1362 a_2052_1479# VSSd 0.0022f
C1363 a_2200_939# VSSd 0.84362f
C1364 a_1620_1479# VSSd 0.64031f
C1365 gf180mcu_fd_sc_mcu7t5v0__mux2_1_0.S VSSd 2.61537f
C1366 a_990_1479# VSSd 0
C1367 a_598_1479# VSSd 0.0022f
C1368 a_746_939# VSSd 0.8236f
C1369 lut_0.gf180mcu_fd_sc_mcu7t5v0__mux2_1_2.Z VSSd 0.53122f
C1370 a_166_1479# VSSd 0.69529f
C1371 lut_0.gf180mcu_fd_sc_mcu7t5v0__mux2_1_3.Z VSSd 0.68236f
C1372 a_2342_1814# VSSd 0.0017f
C1373 a_1414_1814# VSSd 0.00146f
C1374 gf180mcu_fd_sc_mcu7t5v0__mux2_1_0.I1 VSSd 1.07392f
C1375 a_2382_2182# VSSd 0
C1376 a_2390_1770# VSSd 0.87929f
C1377 a_2097_2182# VSSd 0.47503f
C1378 a_1090_1814# VSSd 0.29835f
C1379 a_1462_1770# VSSd 0.42489f
C1380 lut_0.LUT_OUT VSSd 1.00064f
C1381 a_534_2127# VSSd 1.48021f
C1382 CLK2.t5 VSSd 0.04349f
C1383 CLK2.t0 VSSd 0.03706f
C1384 CLK2.n0 VSSd 0.05595f
C1385 CLK2.n1 VSSd 0.22979f
C1386 CLK2.t7 VSSd 0.0358f
C1387 CLK2.t10 VSSd 0.03467f
C1388 CLK2.n2 VSSd 0.06241f
C1389 CLK2.n3 VSSd 0.01339f
C1390 CLK2.n4 VSSd 0.70406f
C1391 CLK2.n5 VSSd 0.25638f
C1392 CLK2.n6 VSSd 0.83052f
C1393 CLK2.t3 VSSd 0.0358f
C1394 CLK2.t6 VSSd 0.03467f
C1395 CLK2.n7 VSSd 0.06241f
C1396 CLK2.n8 VSSd 0.01339f
C1397 CLK2.n9 VSSd 0.07619f
C1398 CLK2.n10 VSSd 0.42052f
C1399 CLK2.n11 VSSd 1.45554f
C1400 CLK2.t11 VSSd 0.0358f
C1401 CLK2.t1 VSSd 0.03467f
C1402 CLK2.n12 VSSd 0.06241f
C1403 CLK2.n13 VSSd 0.01339f
C1404 CLK2.n14 VSSd 0.07619f
C1405 CLK2.n15 VSSd 0.61077f
C1406 CLK2.n16 VSSd 2.08064f
C1407 CLK2.t2 VSSd 0.0358f
C1408 CLK2.t9 VSSd 0.03467f
C1409 CLK2.n17 VSSd 0.06241f
C1410 CLK2.n18 VSSd 0.01339f
C1411 CLK2.n19 VSSd 0.07619f
C1412 CLK2.n20 VSSd 0.8021f
C1413 CLK2.t8 VSSd 0.0358f
C1414 CLK2.t4 VSSd 0.03467f
C1415 CLK2.n21 VSSd 0.06241f
C1416 CLK2.n22 VSSd 0.01339f
C1417 CLK2.n23 VSSd 0.11539f
C1418 CLK2.n24 VSSd 2.70579f
C1419 CLK1.t1 VSSd 0.02862f
C1420 CLK1.t5 VSSd 0.02438f
C1421 CLK1.n0 VSSd 0.03655f
C1422 CLK1.n1 VSSd 0.0245f
C1423 CLK1.t11 VSSd 0.02281f
C1424 CLK1.t7 VSSd 0.02356f
C1425 CLK1.n2 VSSd 0.04133f
C1426 CLK1.n3 VSSd 0.0262f
C1427 CLK1.n4 VSSd 0.01286f
C1428 CLK1.n5 VSSd 0.28413f
C1429 CLK1.n6 VSSd 1.50531f
C1430 CLK1.t3 VSSd 0.02281f
C1431 CLK1.t2 VSSd 0.02356f
C1432 CLK1.n7 VSSd 0.04133f
C1433 CLK1.n8 VSSd 0.0262f
C1434 CLK1.n9 VSSd 0.00697f
C1435 CLK1.n10 VSSd 0.12293f
C1436 CLK1.n11 VSSd 0.43771f
C1437 CLK1.n12 VSSd 1.78939f
C1438 CLK1.t10 VSSd 0.02281f
C1439 CLK1.t0 VSSd 0.02356f
C1440 CLK1.n13 VSSd 0.04133f
C1441 CLK1.n14 VSSd 0.0262f
C1442 CLK1.n15 VSSd 0.00697f
C1443 CLK1.n16 VSSd 0.07562f
C1444 CLK1.n17 VSSd 0.41085f
C1445 CLK1.n18 VSSd 2.60548f
C1446 CLK1.t9 VSSd 0.02281f
C1447 CLK1.t6 VSSd 0.02356f
C1448 CLK1.n19 VSSd 0.04133f
C1449 CLK1.n20 VSSd 0.0262f
C1450 CLK1.n21 VSSd 0.00697f
C1451 CLK1.n22 VSSd 0.07562f
C1452 CLK1.n23 VSSd 0.54064f
C1453 CLK1.t4 VSSd 0.02281f
C1454 CLK1.t8 VSSd 0.02356f
C1455 CLK1.n24 VSSd 0.04133f
C1456 CLK1.n25 VSSd 0.0262f
C1457 CLK1.n26 VSSd 0.00709f
C1458 CLK1.n27 VSSd 0.14728f
C1459 CLK1.n28 VSSd 3.40105f
C1460 a_122_1806.t6 VSSd 0.12223f
C1461 a_122_1806.t3 VSSd 0.38419f
C1462 a_122_1806.t4 VSSd 0.01944f
C1463 a_122_1806.n0 VSSd 0.24674f
C1464 a_122_1806.t1 VSSd 0.10024f
C1465 a_122_1806.n1 VSSd 0.56455f
C1466 a_122_1806.t5 VSSd 0.13823f
C1467 a_122_1806.t7 VSSd 0.12232f
C1468 a_122_1806.n2 VSSd 0.15759f
C1469 a_122_1806.t2 VSSd 0.04083f
C1470 a_122_1806.n3 VSSd 0.05429f
C1471 a_122_1806.n4 VSSd 0.20374f
C1472 a_122_1806.t0 VSSd 0.04561f
C1473 VDDd.n0 VSSd 0.00255f
C1474 VDDd.t102 VSSd 0.00138f
C1475 VDDd.t110 VSSd 0.00138f
C1476 VDDd.n1 VSSd 0.00277f
C1477 VDDd.n2 VSSd 0
C1478 VDDd.t1 VSSd 0.00302f
C1479 VDDd.n3 VSSd 0.0032f
C1480 VDDd.t72 VSSd 0
C1481 VDDd.t4 VSSd 0
C1482 VDDd.n4 VSSd 0.00128f
C1483 VDDd.n5 VSSd 0
C1484 VDDd.t13 VSSd 0.00128f
C1485 VDDd.t115 VSSd 0
C1486 VDDd.n6 VSSd 0.00339f
C1487 VDDd.n7 VSSd 0
C1488 VDDd.t117 VSSd 0.00491f
C1489 VDDd.n8 VSSd 0.00206f
C1490 VDDd.n9 VSSd 0.00268f
C1491 VDDd.n10 VSSd 0.00283f
C1492 VDDd.n11 VSSd 0.00242f
C1493 VDDd.n12 VSSd 0.00151f
C1494 VDDd.n13 VSSd 0.00151f
C1495 VDDd.n14 VSSd 0.00283f
C1496 VDDd.n15 VSSd 0.00268f
C1497 VDDd.n16 VSSd 0.00172f
C1498 VDDd.n17 VSSd 0.00221f
C1499 VDDd.n18 VSSd 0.04095f
C1500 VDDd.t109 VSSd 0.03091f
C1501 VDDd.t101 VSSd 0.05067f
C1502 VDDd.t0 VSSd 0.04581f
C1503 VDDd.t35 VSSd 0.01532f
C1504 VDDd.n19 VSSd 0.04003f
C1505 VDDd.t168 VSSd 0.01769f
C1506 VDDd.t3 VSSd 0.029f
C1507 VDDd.t71 VSSd 0.04103f
C1508 VDDd.t86 VSSd 0.04652f
C1509 VDDd.t2 VSSd 0.03513f
C1510 VDDd.t114 VSSd 0.03218f
C1511 VDDd.t12 VSSd 0.04748f
C1512 VDDd.t116 VSSd 0.05624f
C1513 VDDd.n20 VSSd 0.0607f
C1514 VDDd.n21 VSSd 0.00221f
C1515 VDDd.n22 VSSd 0.00564f
C1516 VDDd.n23 VSSd 0.01353f
C1517 VDDd.n24 VSSd 0.02527f
C1518 VDDd.n25 VSSd 0.03531f
C1519 VDDd.n26 VSSd 0.0237f
C1520 VDDd.n27 VSSd 0.01353f
C1521 VDDd.n28 VSSd 0.00464f
C1522 VDDd.n29 VSSd 0.00255f
C1523 VDDd.n30 VSSd 0.00221f
C1524 VDDd.n31 VSSd 0.00172f
C1525 VDDd.n32 VSSd 0.00268f
C1526 VDDd.n33 VSSd 0.00283f
C1527 VDDd.n34 VSSd 0.00151f
C1528 VDDd.n35 VSSd 0.05268f
C1529 VDDd.n36 VSSd 0.02077f
C1530 VDDd.t123 VSSd 0.00267f
C1531 VDDd.t143 VSSd 0.00256f
C1532 VDDd.n37 VSSd 0.00535f
C1533 VDDd.n38 VSSd 0
C1534 VDDd.t184 VSSd 0
C1535 VDDd.t78 VSSd 0
C1536 VDDd.n39 VSSd 0.00199f
C1537 VDDd.t33 VSSd 0
C1538 VDDd.t149 VSSd 0
C1539 VDDd.n40 VSSd 0.00197f
C1540 VDDd.n41 VSSd 0.00108f
C1541 VDDd.t173 VSSd 0.00256f
C1542 VDDd.t135 VSSd 0.00267f
C1543 VDDd.n42 VSSd 0.00535f
C1544 VDDd.n43 VSSd 0
C1545 VDDd.t167 VSSd 0.00267f
C1546 VDDd.t182 VSSd 0.00256f
C1547 VDDd.n44 VSSd 0.00535f
C1548 VDDd.n45 VSSd 0
C1549 VDDd.t37 VSSd 0
C1550 VDDd.t131 VSSd 0
C1551 VDDd.n46 VSSd 0.00199f
C1552 VDDd.t11 VSSd 0
C1553 VDDd.t47 VSSd 0
C1554 VDDd.n47 VSSd 0.00197f
C1555 VDDd.n48 VSSd 0.00108f
C1556 VDDd.t22 VSSd 0.00256f
C1557 VDDd.t195 VSSd 0.00267f
C1558 VDDd.n49 VSSd 0.00535f
C1559 VDDd.n50 VSSd 0
C1560 VDDd.n51 VSSd 0.00184f
C1561 VDDd.n52 VSSd 0.00151f
C1562 VDDd.t142 VSSd 0.03299f
C1563 VDDd.t77 VSSd 0.03565f
C1564 VDDd.t183 VSSd 0.03046f
C1565 VDDd.t122 VSSd 0.01969f
C1566 VDDd.t79 VSSd 0.02062f
C1567 VDDd.t103 VSSd 0.02714f
C1568 VDDd.t25 VSSd 0.02714f
C1569 VDDd.t89 VSSd 0.02062f
C1570 VDDd.t134 VSSd 0.01969f
C1571 VDDd.t148 VSSd 0.03046f
C1572 VDDd.t32 VSSd 0.03565f
C1573 VDDd.t172 VSSd 0.01969f
C1574 VDDd.t181 VSSd 0.03273f
C1575 VDDd.t130 VSSd 0.03539f
C1576 VDDd.t36 VSSd 0.03073f
C1577 VDDd.t166 VSSd 0.01969f
C1578 VDDd.t129 VSSd 0.02062f
C1579 VDDd.t73 VSSd 0.02714f
C1580 VDDd.t193 VSSd 0.02714f
C1581 VDDd.t34 VSSd 0.02062f
C1582 VDDd.t194 VSSd 0.01969f
C1583 VDDd.t46 VSSd 0.03073f
C1584 VDDd.t10 VSSd 0.03539f
C1585 VDDd.t21 VSSd 0.01942f
C1586 VDDd.n53 VSSd 0.00242f
C1587 VDDd.n54 VSSd 0.00268f
C1588 VDDd.n55 VSSd 0.00283f
C1589 VDDd.n56 VSSd 0.00221f
C1590 VDDd.n57 VSSd 0.08654f
C1591 VDDd.n58 VSSd 0.00262f
C1592 VDDd.n59 VSSd 0.01571f
C1593 VDDd.n60 VSSd 0.00731f
C1594 VDDd.n61 VSSd 0.01571f
C1595 VDDd.n62 VSSd 0.00734f
C1596 VDDd.n63 VSSd 0.00266f
C1597 VDDd.n64 VSSd 0.08564f
C1598 VDDd.n65 VSSd 0.00184f
C1599 VDDd.n66 VSSd 0.00613f
C1600 VDDd.t58 VSSd 0.00491f
C1601 VDDd.n67 VSSd 0.0023f
C1602 VDDd.t91 VSSd 0.00208f
C1603 VDDd.t52 VSSd 0.00155f
C1604 VDDd.n68 VSSd 0.00434f
C1605 VDDd.n69 VSSd 0
C1606 VDDd.t126 VSSd 0.00205f
C1607 VDDd.t60 VSSd 0.00148f
C1608 VDDd.n70 VSSd 0.00353f
C1609 VDDd.n71 VSSd 0
C1610 VDDd.t54 VSSd 0.00255f
C1611 VDDd.n72 VSSd 0.00162f
C1612 VDDd.t41 VSSd 0.00258f
C1613 VDDd.t48 VSSd 0.00148f
C1614 VDDd.t29 VSSd 0.00205f
C1615 VDDd.n73 VSSd 0.00353f
C1616 VDDd.n74 VSSd 0
C1617 VDDd.t163 VSSd 0.00155f
C1618 VDDd.t6 VSSd 0.00208f
C1619 VDDd.n75 VSSd 0.00434f
C1620 VDDd.n76 VSSd 0
C1621 VDDd.t50 VSSd 0.00491f
C1622 VDDd.n77 VSSd 0.0023f
C1623 VDDd.n78 VSSd 0.00184f
C1624 VDDd.n79 VSSd 0.00196f
C1625 VDDd.n80 VSSd 0.00283f
C1626 VDDd.t5 VSSd 0.03093f
C1627 VDDd.n81 VSSd 0.00196f
C1628 VDDd.n82 VSSd 0.15852f
C1629 VDDd.t162 VSSd 0.01785f
C1630 VDDd.t59 VSSd 0.01785f
C1631 VDDd.t57 VSSd 0.04462f
C1632 VDDd.n83 VSSd 0.10351f
C1633 VDDd.n84 VSSd 0.00283f
C1634 VDDd.n85 VSSd 0.00221f
C1635 VDDd.n86 VSSd 0.00221f
C1636 VDDd.t90 VSSd 0.01368f
C1637 VDDd.n87 VSSd 0.00221f
C1638 VDDd.n88 VSSd 0.00172f
C1639 VDDd.n89 VSSd 0.00268f
C1640 VDDd.t53 VSSd 0.01785f
C1641 VDDd.t28 VSSd 0.0351f
C1642 VDDd.t49 VSSd 0.04521f
C1643 VDDd.n90 VSSd 0.00283f
C1644 VDDd.n91 VSSd 0.00268f
C1645 VDDd.n92 VSSd 0.00172f
C1646 VDDd.n93 VSSd 0.00221f
C1647 VDDd.n94 VSSd 0.15705f
C1648 VDDd.n95 VSSd 0.10351f
C1649 VDDd.n96 VSSd 0.00283f
C1650 VDDd.n97 VSSd 0.00221f
C1651 VDDd.n98 VSSd 0.04759f
C1652 VDDd.n99 VSSd 0.10767f
C1653 VDDd.n100 VSSd 0.00221f
C1654 VDDd.n101 VSSd 0.00613f
C1655 VDDd.n102 VSSd 0.00264f
C1656 VDDd.n103 VSSd 0.00585f
C1657 VDDd.n104 VSSd 0.00884f
C1658 VDDd.n105 VSSd 0.01631f
C1659 VDDd.n106 VSSd 0.0112f
C1660 VDDd.n107 VSSd 0.00264f
C1661 VDDd.n108 VSSd 0.05981f
C1662 VDDd.n109 VSSd 0.00184f
C1663 VDDd.n110 VSSd 0.00613f
C1664 VDDd.t68 VSSd 0.00491f
C1665 VDDd.n111 VSSd 0.0023f
C1666 VDDd.t20 VSSd 0.00208f
C1667 VDDd.t27 VSSd 0.00155f
C1668 VDDd.n112 VSSd 0.00434f
C1669 VDDd.n113 VSSd 0
C1670 VDDd.t80 VSSd 0.00205f
C1671 VDDd.t70 VSSd 0.00148f
C1672 VDDd.n114 VSSd 0.00353f
C1673 VDDd.n115 VSSd 0
C1674 VDDd.t81 VSSd 0.00255f
C1675 VDDd.n116 VSSd 0.00162f
C1676 VDDd.t45 VSSd 0.00258f
C1677 VDDd.t106 VSSd 0.00148f
C1678 VDDd.t157 VSSd 0.00205f
C1679 VDDd.n117 VSSd 0.00353f
C1680 VDDd.n118 VSSd 0
C1681 VDDd.t66 VSSd 0.00155f
C1682 VDDd.t51 VSSd 0.00208f
C1683 VDDd.n119 VSSd 0.00434f
C1684 VDDd.n120 VSSd 0
C1685 VDDd.t108 VSSd 0.00491f
C1686 VDDd.n121 VSSd 0.0023f
C1687 VDDd.n122 VSSd 0.00184f
C1688 VDDd.n123 VSSd 0.00196f
C1689 VDDd.n124 VSSd 0.00283f
C1690 VDDd.t44 VSSd 0.03093f
C1691 VDDd.n125 VSSd 0.00196f
C1692 VDDd.n126 VSSd 0.15852f
C1693 VDDd.t65 VSSd 0.01785f
C1694 VDDd.t69 VSSd 0.01785f
C1695 VDDd.t67 VSSd 0.04462f
C1696 VDDd.n127 VSSd 0.10351f
C1697 VDDd.n128 VSSd 0.00283f
C1698 VDDd.n129 VSSd 0.00221f
C1699 VDDd.n130 VSSd 0.00221f
C1700 VDDd.t19 VSSd 0.01368f
C1701 VDDd.n131 VSSd 0.00221f
C1702 VDDd.n132 VSSd 0.00172f
C1703 VDDd.n133 VSSd 0.00268f
C1704 VDDd.t18 VSSd 0.01785f
C1705 VDDd.t26 VSSd 0.0351f
C1706 VDDd.t107 VSSd 0.04521f
C1707 VDDd.n134 VSSd 0.00283f
C1708 VDDd.n135 VSSd 0.00268f
C1709 VDDd.n136 VSSd 0.00172f
C1710 VDDd.n137 VSSd 0.00221f
C1711 VDDd.n138 VSSd 0.15705f
C1712 VDDd.n139 VSSd 0.10351f
C1713 VDDd.n140 VSSd 0.00283f
C1714 VDDd.n141 VSSd 0.00221f
C1715 VDDd.n142 VSSd 0.04759f
C1716 VDDd.n143 VSSd 0.10767f
C1717 VDDd.n144 VSSd 0.00221f
C1718 VDDd.n145 VSSd 0.00613f
C1719 VDDd.n146 VSSd 0.00264f
C1720 VDDd.n147 VSSd 0.00585f
C1721 VDDd.n148 VSSd 0.00884f
C1722 VDDd.n149 VSSd 0.01631f
C1723 VDDd.n150 VSSd 0.0112f
C1724 VDDd.n151 VSSd 0.00264f
C1725 VDDd.n152 VSSd 0.05981f
C1726 VDDd.n153 VSSd 0.00184f
C1727 VDDd.n154 VSSd 0.00151f
C1728 VDDd.n155 VSSd 0.00242f
C1729 VDDd.n156 VSSd 0.00268f
C1730 VDDd.n157 VSSd 0.00283f
C1731 VDDd.n158 VSSd 0.00221f
C1732 VDDd.n159 VSSd 0.05262f
C1733 VDDd.n160 VSSd 0.02075f
C1734 VDDd.t159 VSSd 0.00491f
C1735 VDDd.n161 VSSd 0.0023f
C1736 VDDd.t176 VSSd 0.00208f
C1737 VDDd.t17 VSSd 0.00155f
C1738 VDDd.n162 VSSd 0.00434f
C1739 VDDd.n163 VSSd 0
C1740 VDDd.t15 VSSd 0.00205f
C1741 VDDd.t161 VSSd 0.00148f
C1742 VDDd.n164 VSSd 0.00353f
C1743 VDDd.n165 VSSd 0
C1744 VDDd.t156 VSSd 0.00255f
C1745 VDDd.n166 VSSd 0.00162f
C1746 VDDd.t165 VSSd 0.00258f
C1747 VDDd.t100 VSSd 0.00148f
C1748 VDDd.t56 VSSd 0.00205f
C1749 VDDd.n167 VSSd 0.00353f
C1750 VDDd.n168 VSSd 0
C1751 VDDd.t93 VSSd 0.00155f
C1752 VDDd.t9 VSSd 0.00208f
C1753 VDDd.n169 VSSd 0.00434f
C1754 VDDd.n170 VSSd 0
C1755 VDDd.t98 VSSd 0.00491f
C1756 VDDd.n171 VSSd 0.0023f
C1757 VDDd.t64 VSSd 0.00491f
C1758 VDDd.n172 VSSd 0.00324f
C1759 VDDd.t30 VSSd 0.2041f
C1760 VDDd.t63 VSSd 0.04544f
C1761 VDDd.t16 VSSd 0.02445f
C1762 VDDd.t158 VSSd 0.03455f
C1763 VDDd.t175 VSSd 0.0489f
C1764 VDDd.t160 VSSd 0.04677f
C1765 VDDd.t14 VSSd 0.03455f
C1766 VDDd.t155 VSSd 0.02445f
C1767 VDDd.t174 VSSd 0.03242f
C1768 VDDd.t136 VSSd 0.02711f
C1769 VDDd.t141 VSSd 0.02711f
C1770 VDDd.t7 VSSd 0.03242f
C1771 VDDd.t164 VSSd 0.02445f
C1772 VDDd.t55 VSSd 0.03455f
C1773 VDDd.t99 VSSd 0.04677f
C1774 VDDd.t8 VSSd 0.0489f
C1775 VDDd.t97 VSSd 0.03455f
C1776 VDDd.t92 VSSd 0.01116f
C1777 VDDd.n173 VSSd 0.02846f
C1778 VDDd.t31 VSSd 0.00491f
C1779 VDDd.n174 VSSd 0.0084f
C1780 VDDd.n175 VSSd 0.00305f
C1781 VDDd.n176 VSSd 0.00585f
C1782 VDDd.n177 VSSd 0.00884f
C1783 VDDd.n178 VSSd 0.01631f
C1784 VDDd.n179 VSSd 0.0112f
C1785 VDDd.n180 VSSd 0.00266f
C1786 VDDd.n181 VSSd 0.00351f
C1787 VDDd.n182 VSSd 0.05977f
C1788 VDDd.n183 VSSd 0.00184f
C1789 VDDd.n184 VSSd 0.00151f
C1790 VDDd.n185 VSSd 0.00242f
C1791 VDDd.n186 VSSd 0.00268f
C1792 VDDd.n187 VSSd 0.00283f
C1793 VDDd.n188 VSSd 0.00221f
C1794 VDDd.n189 VSSd 0.05262f
C1795 VDDd.n190 VSSd 0.02075f
C1796 VDDd.t190 VSSd 0.00491f
C1797 VDDd.n191 VSSd 0.0023f
C1798 VDDd.t76 VSSd 0.00208f
C1799 VDDd.t88 VSSd 0.00155f
C1800 VDDd.n192 VSSd 0.00434f
C1801 VDDd.n193 VSSd 0
C1802 VDDd.t125 VSSd 0.00205f
C1803 VDDd.t192 VSSd 0.00148f
C1804 VDDd.n194 VSSd 0.00353f
C1805 VDDd.n195 VSSd 0
C1806 VDDd.t186 VSSd 0.00255f
C1807 VDDd.n196 VSSd 0.00162f
C1808 VDDd.t147 VSSd 0.00258f
C1809 VDDd.t154 VSSd 0.00148f
C1810 VDDd.t105 VSSd 0.00205f
C1811 VDDd.n197 VSSd 0.00353f
C1812 VDDd.n198 VSSd 0
C1813 VDDd.t128 VSSd 0.00155f
C1814 VDDd.t112 VSSd 0.00208f
C1815 VDDd.n199 VSSd 0.00434f
C1816 VDDd.n200 VSSd 0
C1817 VDDd.t152 VSSd 0.00491f
C1818 VDDd.n201 VSSd 0.0023f
C1819 VDDd.t145 VSSd 0.00491f
C1820 VDDd.n202 VSSd 0.00324f
C1821 VDDd.t118 VSSd 0.2041f
C1822 VDDd.t144 VSSd 0.04544f
C1823 VDDd.t87 VSSd 0.02445f
C1824 VDDd.t189 VSSd 0.03455f
C1825 VDDd.t75 VSSd 0.0489f
C1826 VDDd.t191 VSSd 0.04677f
C1827 VDDd.t124 VSSd 0.03455f
C1828 VDDd.t185 VSSd 0.02445f
C1829 VDDd.t74 VSSd 0.03242f
C1830 VDDd.t24 VSSd 0.02711f
C1831 VDDd.t150 VSSd 0.02711f
C1832 VDDd.t113 VSSd 0.03242f
C1833 VDDd.t146 VSSd 0.02445f
C1834 VDDd.t104 VSSd 0.03455f
C1835 VDDd.t153 VSSd 0.04677f
C1836 VDDd.t111 VSSd 0.0489f
C1837 VDDd.t151 VSSd 0.03455f
C1838 VDDd.t127 VSSd 0.01116f
C1839 VDDd.n203 VSSd 0.02846f
C1840 VDDd.t119 VSSd 0.00491f
C1841 VDDd.n204 VSSd 0.0084f
C1842 VDDd.n205 VSSd 0.00305f
C1843 VDDd.n206 VSSd 0.00585f
C1844 VDDd.n207 VSSd 0.00884f
C1845 VDDd.n208 VSSd 0.01631f
C1846 VDDd.n209 VSSd 0.0112f
C1847 VDDd.n210 VSSd 0.00264f
C1848 VDDd.n211 VSSd 0.05978f
C1849 VDDd.n212 VSSd 0.04604f
C1850 VDDd.n213 VSSd 0.00255f
C1851 VDDd.n214 VSSd 0.00221f
C1852 VDDd.n215 VSSd 0.00172f
C1853 VDDd.n216 VSSd 0.00268f
C1854 VDDd.n217 VSSd 0.00283f
C1855 VDDd.n218 VSSd 0.00151f
C1856 VDDd.n219 VSSd 0.05262f
C1857 VDDd.n220 VSSd 0.02075f
C1858 VDDd.t178 VSSd 0.00491f
C1859 VDDd.n221 VSSd 0.0023f
C1860 VDDd.t40 VSSd 0.00208f
C1861 VDDd.t171 VSSd 0.00155f
C1862 VDDd.n222 VSSd 0.00434f
C1863 VDDd.n223 VSSd 0
C1864 VDDd.t43 VSSd 0.00205f
C1865 VDDd.t180 VSSd 0.00148f
C1866 VDDd.n224 VSSd 0.00353f
C1867 VDDd.n225 VSSd 0
C1868 VDDd.t188 VSSd 0.00255f
C1869 VDDd.n226 VSSd 0.00162f
C1870 VDDd.t121 VSSd 0.00258f
C1871 VDDd.t85 VSSd 0.00148f
C1872 VDDd.t140 VSSd 0.00205f
C1873 VDDd.n227 VSSd 0.00353f
C1874 VDDd.n228 VSSd 0
C1875 VDDd.t138 VSSd 0.00155f
C1876 VDDd.t96 VSSd 0.00208f
C1877 VDDd.n229 VSSd 0.00434f
C1878 VDDd.n230 VSSd 0
C1879 VDDd.t83 VSSd 0.00491f
C1880 VDDd.n231 VSSd 0.0023f
C1881 VDDd.t133 VSSd 0.00491f
C1882 VDDd.n232 VSSd 0.00324f
C1883 VDDd.t170 VSSd 0.02445f
C1884 VDDd.t177 VSSd 0.03455f
C1885 VDDd.t39 VSSd 0.0489f
C1886 VDDd.t179 VSSd 0.04677f
C1887 VDDd.t42 VSSd 0.03455f
C1888 VDDd.t187 VSSd 0.02445f
C1889 VDDd.t38 VSSd 0.03242f
C1890 VDDd.t169 VSSd 0.02711f
C1891 VDDd.t23 VSSd 0.02711f
C1892 VDDd.t94 VSSd 0.03242f
C1893 VDDd.t120 VSSd 0.02445f
C1894 VDDd.t139 VSSd 0.03455f
C1895 VDDd.t84 VSSd 0.04677f
C1896 VDDd.t95 VSSd 0.0489f
C1897 VDDd.t82 VSSd 0.03455f
C1898 VDDd.t137 VSSd 0.01116f
C1899 VDDd.n233 VSSd 0.02846f
C1900 VDDd.t62 VSSd 0.00491f
C1901 VDDd.n234 VSSd 0.00324f
C1902 VDDd.n235 VSSd 0.00268f
C1903 VDDd.n236 VSSd 0.00283f
C1904 VDDd.n237 VSSd 0.00242f
C1905 VDDd.n238 VSSd 0.00151f
C1906 VDDd.t132 VSSd 0.04544f
C1907 VDDd.t61 VSSd 0.07255f
C1908 VDDd.n239 VSSd 0.13155f
C1909 VDDd.n240 VSSd 0.00221f
C1910 VDDd.n241 VSSd 0.00566f
C1911 VDDd.n242 VSSd 0.00918f
C1912 VDDd.n243 VSSd 0.00305f
C1913 VDDd.n244 VSSd 0.00585f
C1914 VDDd.n245 VSSd 0.00884f
C1915 VDDd.n246 VSSd 0.01631f
C1916 VDDd.n247 VSSd 0.0112f
C1917 VDDd.n248 VSSd 0.00265f
.ends
