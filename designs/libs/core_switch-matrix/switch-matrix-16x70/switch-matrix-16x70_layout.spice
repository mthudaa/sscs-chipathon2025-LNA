* NGSPICE file created from switch-matrix-16x70.ext - technology: gf180mcuD

.subckt nfet_06v0_42FNXL a_436_n400# a_192_n400# a_n436_n444# a_n768_n400# a_n192_n444#
+ a_540_n444# a_n296_n400# a_n52_n400# a_680_n400# a_n680_n444# a_n540_n400# a_296_n444#
+ a_52_n444# VSUBS
X0 a_436_n400# a_296_n444# a_192_n400# VSUBS nfet_06v0 ad=1.04p pd=4.52u as=1.04p ps=4.52u w=4u l=0.7u
X1 a_680_n400# a_540_n444# a_436_n400# VSUBS nfet_06v0 ad=1.76p pd=8.88u as=1.04p ps=4.52u w=4u l=0.7u
X2 a_192_n400# a_52_n444# a_n52_n400# VSUBS nfet_06v0 ad=1.04p pd=4.52u as=1.04p ps=4.52u w=4u l=0.7u
X3 a_n52_n400# a_n192_n444# a_n296_n400# VSUBS nfet_06v0 ad=1.04p pd=4.52u as=1.04p ps=4.52u w=4u l=0.7u
X4 a_n296_n400# a_n436_n444# a_n540_n400# VSUBS nfet_06v0 ad=1.04p pd=4.52u as=1.04p ps=4.52u w=4u l=0.7u
X5 a_n540_n400# a_n680_n444# a_n768_n400# VSUBS nfet_06v0 ad=1.04p pd=4.52u as=1.76p ps=8.88u w=4u l=0.7u
.ends

.subckt pfet_06v0_LJSS4L a_376_n400# a_1764_n444# a_n590_n444# a_1122_n444# a_n376_n444#
+ a_908_n444# w_n2048_n530# a_n694_n400# a_480_n444# a_266_n444# a_n1660_n444# a_n1446_n444#
+ a_1660_n400# a_n52_n400# a_n1764_n400# a_1446_n400# a_804_n400# a_n1122_n400# a_1550_n444#
+ a_162_n400# a_1336_n444# a_n804_n444# a_694_n444# a_n162_n444# a_n480_n400# a_n908_n400#
+ a_n1874_n444# a_n266_n400# a_1874_n400# a_n1962_n400# a_52_n444# a_n1232_n444# a_1232_n400#
+ a_n1550_n400# a_n1018_n444# a_n1336_n400# a_1018_n400# a_590_n400#
X0 a_376_n400# a_266_n444# a_162_n400# w_n2048_n530# pfet_06v0 ad=1.04p pd=4.52u as=1.04p ps=4.52u w=4u l=0.55u
X1 a_1232_n400# a_1122_n444# a_1018_n400# w_n2048_n530# pfet_06v0 ad=1.04p pd=4.52u as=1.04p ps=4.52u w=4u l=0.55u
X2 a_n694_n400# a_n804_n444# a_n908_n400# w_n2048_n530# pfet_06v0 ad=1.04p pd=4.52u as=1.04p ps=4.52u w=4u l=0.55u
X3 a_n1550_n400# a_n1660_n444# a_n1764_n400# w_n2048_n530# pfet_06v0 ad=1.04p pd=4.52u as=1.04p ps=4.52u w=4u l=0.55u
X4 a_1446_n400# a_1336_n444# a_1232_n400# w_n2048_n530# pfet_06v0 ad=1.04p pd=4.52u as=1.04p ps=4.52u w=4u l=0.55u
X5 a_n908_n400# a_n1018_n444# a_n1122_n400# w_n2048_n530# pfet_06v0 ad=1.04p pd=4.52u as=1.04p ps=4.52u w=4u l=0.55u
X6 a_n52_n400# a_n162_n444# a_n266_n400# w_n2048_n530# pfet_06v0 ad=1.04p pd=4.52u as=1.04p ps=4.52u w=4u l=0.55u
X7 a_162_n400# a_52_n444# a_n52_n400# w_n2048_n530# pfet_06v0 ad=1.04p pd=4.52u as=1.04p ps=4.52u w=4u l=0.55u
X8 a_590_n400# a_480_n444# a_376_n400# w_n2048_n530# pfet_06v0 ad=1.04p pd=4.52u as=1.04p ps=4.52u w=4u l=0.55u
X9 a_n1764_n400# a_n1874_n444# a_n1962_n400# w_n2048_n530# pfet_06v0 ad=1.04p pd=4.52u as=1.76p ps=8.88u w=4u l=0.55u
X10 a_1018_n400# a_908_n444# a_804_n400# w_n2048_n530# pfet_06v0 ad=1.04p pd=4.52u as=1.04p ps=4.52u w=4u l=0.55u
X11 a_n266_n400# a_n376_n444# a_n480_n400# w_n2048_n530# pfet_06v0 ad=1.04p pd=4.52u as=1.04p ps=4.52u w=4u l=0.55u
X12 a_804_n400# a_694_n444# a_590_n400# w_n2048_n530# pfet_06v0 ad=1.04p pd=4.52u as=1.04p ps=4.52u w=4u l=0.55u
X13 a_1660_n400# a_1550_n444# a_1446_n400# w_n2048_n530# pfet_06v0 ad=1.04p pd=4.52u as=1.04p ps=4.52u w=4u l=0.55u
X14 a_n1122_n400# a_n1232_n444# a_n1336_n400# w_n2048_n530# pfet_06v0 ad=1.04p pd=4.52u as=1.04p ps=4.52u w=4u l=0.55u
X15 a_n480_n400# a_n590_n444# a_n694_n400# w_n2048_n530# pfet_06v0 ad=1.04p pd=4.52u as=1.04p ps=4.52u w=4u l=0.55u
X16 a_1874_n400# a_1764_n444# a_1660_n400# w_n2048_n530# pfet_06v0 ad=1.76p pd=8.88u as=1.04p ps=4.52u w=4u l=0.55u
X17 a_n1336_n400# a_n1446_n444# a_n1550_n400# w_n2048_n530# pfet_06v0 ad=1.04p pd=4.52u as=1.04p ps=4.52u w=4u l=0.55u
.ends

.subckt trans-gate SWP IN OUT VDD VSS SWN
Xnfet_06v0_42FNXL_0 IN OUT SWN OUT SWN SWN OUT IN OUT SWN IN SWN SWN VSS nfet_06v0_42FNXL
Xpfet_06v0_LJSS4L_0 OUT SWP SWP SWP SWP SWP VDD IN SWP SWP SWP SWP OUT OUT OUT IN
+ OUT IN SWP IN SWP SWP SWP SWP OUT OUT SWP IN IN IN SWP SWP OUT IN SWP OUT IN IN
+ pfet_06v0_LJSS4L
.ends

.subckt gf180mcu_fd_sc_mcu9t5v0__latq_1 D E Q VDD VNW VPW VSS
X0 VSS a_1020_652# Q VPW nfet_06v0 ad=0.5808p pd=3.52u as=0.5808p ps=3.52u w=1.32u l=0.6u
X1 a_504_110# a_36_92# VDD VNW pfet_06v0 ad=0.44p pd=2.88u as=0.476p ps=2.18u w=1u l=0.5u
X2 VDD a_1020_652# Q VNW pfet_06v0 ad=0.8052p pd=4.54u as=0.8052p ps=4.54u w=1.83u l=0.5u
X3 a_1264_107# a_36_92# a_1020_652# VPW nfet_06v0 ad=0.263p pd=1.49u as=0.182p ps=1.22u w=0.7u l=0.6u
X4 VSS E a_36_92# VPW nfet_06v0 ad=0.263p pd=1.49u as=0.3476p ps=2.46u w=0.79u l=0.6u
X5 VSS a_1364_532# a_1264_107# VPW nfet_06v0 ad=0.2054p pd=1.31u as=0.263p ps=1.49u w=0.79u l=0.6u
X6 VDD E a_36_92# VNW pfet_06v0 ad=0.476p pd=2.18u as=0.6072p ps=3.64u w=1.38u l=0.5u
X7 VDD a_1364_532# a_1224_652# VNW pfet_06v0 ad=0.3588p pd=1.9u as=0.426p ps=2.08u w=1.38u l=0.5u
X8 a_872_652# D VDD VNW pfet_06v0 ad=0.12p pd=1.24u as=0.44p ps=2.88u w=1u l=0.5u
X9 a_1364_532# a_1020_652# VDD VNW pfet_06v0 ad=0.6072p pd=3.64u as=0.3588p ps=1.9u w=1.38u l=0.5u
X10 a_1020_652# a_504_110# a_872_107# VPW nfet_06v0 ad=0.182p pd=1.22u as=83.99999f ps=0.94u w=0.7u l=0.6u
X11 a_872_107# D VSS VPW nfet_06v0 ad=83.99999f pd=0.94u as=0.308p ps=2.28u w=0.7u l=0.6u
X12 a_1020_652# a_36_92# a_872_652# VNW pfet_06v0 ad=0.26p pd=1.52u as=0.12p ps=1.24u w=1u l=0.5u
X13 a_504_110# a_36_92# VSS VPW nfet_06v0 ad=0.308p pd=2.28u as=0.263p ps=1.49u w=0.7u l=0.6u
X14 a_1364_532# a_1020_652# VSS VPW nfet_06v0 ad=0.3476p pd=2.46u as=0.2054p ps=1.31u w=0.79u l=0.6u
X15 a_1224_652# a_504_110# a_1020_652# VNW pfet_06v0 ad=0.426p pd=2.08u as=0.26p ps=1.52u w=1u l=0.5u
.ends

.subckt gf180mcu_fd_sc_mcu9t5v0__inv_1 I ZN VDD VNW VPW VSS
X0 ZN I VDD VNW pfet_06v0 ad=0.8052p pd=4.54u as=0.8052p ps=4.54u w=1.83u l=0.5u
X1 ZN I VSS VPW nfet_06v0 ad=0.5808p pd=3.52u as=0.5808p ps=3.52u w=1.32u l=0.6u
.ends

.subckt gf180mcu_fd_sc_mcu9t5v0__and2_1 A1 A2 Z VDD VNW VPW VSS
X0 VDD A2 a_36_201# VNW pfet_06v0 ad=0.5054p pd=2.57u as=0.2132p ps=1.34u w=0.82u l=0.5u
X1 a_244_201# A1 a_36_201# VPW nfet_06v0 ad=0.1056p pd=0.98u as=0.2904p ps=2.2u w=0.66u l=0.6u
X2 Z a_36_201# VSS VPW nfet_06v0 ad=0.5808p pd=3.52u as=0.3894p ps=2.06u w=1.32u l=0.6u
X3 Z a_36_201# VDD VNW pfet_06v0 ad=0.8052p pd=4.54u as=0.5054p ps=2.57u w=1.83u l=0.5u
X4 VSS A2 a_244_201# VPW nfet_06v0 ad=0.3894p pd=2.06u as=0.1056p ps=0.98u w=0.66u l=0.6u
X5 a_36_201# A1 VDD VNW pfet_06v0 ad=0.2132p pd=1.34u as=0.3608p ps=2.52u w=0.82u l=0.5u
.ends

.subckt switch-cell VDD CLK1 Q D OUT CLK2 IN RSTN VSS
Xtrans-gate_0 trans-gate_0/SWP IN OUT VDD VSS trans-gate_0/SWN trans-gate
Xgf180mcu_fd_sc_mcu9t5v0__latq_1_0 D CLK1 gf180mcu_fd_sc_mcu9t5v0__latq_1_1/D VDD
+ VDD VSS VSS gf180mcu_fd_sc_mcu9t5v0__latq_1
Xgf180mcu_fd_sc_mcu9t5v0__latq_1_1 gf180mcu_fd_sc_mcu9t5v0__latq_1_1/D CLK2 Q VDD
+ VDD VSS VSS gf180mcu_fd_sc_mcu9t5v0__latq_1
Xgf180mcu_fd_sc_mcu9t5v0__inv_1_0 trans-gate_0/SWN trans-gate_0/SWP VDD VDD VSS VSS
+ gf180mcu_fd_sc_mcu9t5v0__inv_1
Xgf180mcu_fd_sc_mcu9t5v0__and2_1_0 Q RSTN trans-gate_0/SWN VDD VDD VSS VSS gf180mcu_fd_sc_mcu9t5v0__and2_1
.ends

.subckt switch-matrix-16x1 OUT[4] OUT[9] OUT[13] VDD RSTN CLK1 IN Q D OUT[6] OUT[7]
+ OUT[0] OUT[12] OUT[5] OUT[15] CLK2 OUT[10] OUT[8] OUT[1] OUT[11] OUT[2] OUT[14]
+ VSS OUT[3]
Xswitch-cell_15 VDD CLK1 Q switch-cell_16/Q OUT[0] CLK2 IN RSTN VSS switch-cell
Xswitch-cell_0 VDD CLK1 switch-cell_1/D D OUT[15] CLK2 IN RSTN VSS switch-cell
Xswitch-cell_16 VDD CLK1 switch-cell_16/Q switch-cell_16/D OUT[1] CLK2 IN RSTN VSS
+ switch-cell
Xswitch-cell_1 VDD CLK1 switch-cell_2/D switch-cell_1/D OUT[14] CLK2 IN RSTN VSS switch-cell
Xswitch-cell_2 VDD CLK1 switch-cell_3/D switch-cell_2/D OUT[13] CLK2 IN RSTN VSS switch-cell
Xswitch-cell_3 VDD CLK1 switch-cell_4/D switch-cell_3/D OUT[12] CLK2 IN RSTN VSS switch-cell
Xswitch-cell_4 VDD CLK1 switch-cell_5/D switch-cell_4/D OUT[11] CLK2 IN RSTN VSS switch-cell
Xswitch-cell_5 VDD CLK1 switch-cell_8/D switch-cell_5/D OUT[10] CLK2 IN RSTN VSS switch-cell
Xswitch-cell_6 VDD CLK1 switch-cell_9/D switch-cell_7/Q OUT[7] CLK2 IN RSTN VSS switch-cell
Xswitch-cell_7 VDD CLK1 switch-cell_7/Q switch-cell_8/Q OUT[8] CLK2 IN RSTN VSS switch-cell
Xswitch-cell_8 VDD CLK1 switch-cell_8/Q switch-cell_8/D OUT[9] CLK2 IN RSTN VSS switch-cell
Xswitch-cell_9 VDD CLK1 switch-cell_9/Q switch-cell_9/D OUT[6] CLK2 IN RSTN VSS switch-cell
Xswitch-cell_10 VDD CLK1 switch-cell_13/D switch-cell_11/Q OUT[3] CLK2 IN RSTN VSS
+ switch-cell
Xswitch-cell_11 VDD CLK1 switch-cell_11/Q switch-cell_12/Q OUT[4] CLK2 IN RSTN VSS
+ switch-cell
Xswitch-cell_13 VDD CLK1 switch-cell_16/D switch-cell_13/D OUT[2] CLK2 IN RSTN VSS
+ switch-cell
Xswitch-cell_12 VDD CLK1 switch-cell_12/Q switch-cell_9/Q OUT[5] CLK2 IN RSTN VSS
+ switch-cell
.ends

.subckt switch-matrix-16x70 VSS VDD RSTN CLK2 CLK1 D Q OUT[15] OUT[14] OUT[13] OUT[12]
+ OUT[11] OUT[10] OUT[9] OUT[8] OUT[7] OUT[6] OUT[5] OUT[4] OUT[3] OUT[2] OUT[1] OUT[0]
+ IN[75] IN[73] IN[72] IN[71] IN[70] IN[69] IN[68] IN[67] IN[66] IN[65] IN[64] IN[63]
+ IN[62] IN[61] IN[60] IN[59] IN[58] IN[57] IN[56] IN[55] IN[54] IN[53] IN[52] IN[51]
+ IN[50] IN[49] IN[48] IN[47] IN[46] IN[45] IN[44] IN[43] IN[42] IN[41] IN[40] IN[39]
+ IN[38] IN[37] IN[36] IN[35] IN[34] IN[33] IN[32] IN[31] IN[30] IN[29] IN[28] IN[27]
+ IN[26] IN[25] IN[24] IN[23] IN[22] IN[21] IN[20] IN[19] IN[18] IN[17] IN[16] IN[15]
+ IN[14] IN[13] IN[12] IN[11] IN[10] IN[9] IN[8] IN[7] IN[6] IN[5] IN[4] IN[3] IN[2]
+ IN[1] IN[0] IN[74]
Xswitch-matrix-16x1_70 OUT[4] OUT[9] OUT[13] VDD RSTN CLK1 IN[0] Q switch-matrix-16x1_71/Q
+ OUT[6] OUT[7] OUT[0] OUT[12] OUT[5] OUT[15] CLK2 OUT[10] OUT[8] OUT[1] OUT[11] OUT[2]
+ OUT[14] VSS OUT[3] switch-matrix-16x1
Xswitch-matrix-16x1_60 OUT[4] OUT[9] OUT[13] VDD RSTN CLK1 IN[75] switch-matrix-16x1_61/D
+ D OUT[6] OUT[7] OUT[0] OUT[12] OUT[5] OUT[15] CLK2 OUT[10] OUT[8] OUT[1] OUT[11]
+ OUT[2] OUT[14] VSS OUT[3] switch-matrix-16x1
Xswitch-matrix-16x1_61 OUT[4] OUT[9] OUT[13] VDD RSTN CLK1 IN[74] switch-matrix-16x1_62/D
+ switch-matrix-16x1_61/D OUT[6] OUT[7] OUT[0] OUT[12] OUT[5] OUT[15] CLK2 OUT[10]
+ OUT[8] OUT[1] OUT[11] OUT[2] OUT[14] VSS OUT[3] switch-matrix-16x1
Xswitch-matrix-16x1_50 OUT[4] OUT[9] OUT[13] VDD RSTN CLK1 IN[56] switch-matrix-16x1_50/Q
+ switch-matrix-16x1_51/Q OUT[6] OUT[7] OUT[0] OUT[12] OUT[5] OUT[15] CLK2 OUT[10]
+ OUT[8] OUT[1] OUT[11] OUT[2] OUT[14] VSS OUT[3] switch-matrix-16x1
Xswitch-matrix-16x1_72 OUT[4] OUT[9] OUT[13] VDD RSTN CLK1 IN[2] switch-matrix-16x1_72/Q
+ switch-matrix-16x1_73/Q OUT[6] OUT[7] OUT[0] OUT[12] OUT[5] OUT[15] CLK2 OUT[10]
+ OUT[8] OUT[1] OUT[11] OUT[2] OUT[14] VSS OUT[3] switch-matrix-16x1
Xswitch-matrix-16x1_71 OUT[4] OUT[9] OUT[13] VDD RSTN CLK1 IN[1] switch-matrix-16x1_71/Q
+ switch-matrix-16x1_72/Q OUT[6] OUT[7] OUT[0] OUT[12] OUT[5] OUT[15] CLK2 OUT[10]
+ OUT[8] OUT[1] OUT[11] OUT[2] OUT[14] VSS OUT[3] switch-matrix-16x1
Xswitch-matrix-16x1_62 OUT[4] OUT[9] OUT[13] VDD RSTN CLK1 IN[73] switch-matrix-16x1_63/D
+ switch-matrix-16x1_62/D OUT[6] OUT[7] OUT[0] OUT[12] OUT[5] OUT[15] CLK2 OUT[10]
+ OUT[8] OUT[1] OUT[11] OUT[2] OUT[14] VSS OUT[3] switch-matrix-16x1
Xswitch-matrix-16x1_51 OUT[4] OUT[9] OUT[13] VDD RSTN CLK1 IN[57] switch-matrix-16x1_51/Q
+ switch-matrix-16x1_52/Q OUT[6] OUT[7] OUT[0] OUT[12] OUT[5] OUT[15] CLK2 OUT[10]
+ OUT[8] OUT[1] OUT[11] OUT[2] OUT[14] VSS OUT[3] switch-matrix-16x1
Xswitch-matrix-16x1_40 OUT[4] OUT[9] OUT[13] VDD RSTN CLK1 IN[55] switch-matrix-16x1_41/D
+ switch-matrix-16x1_50/Q OUT[6] OUT[7] OUT[0] OUT[12] OUT[5] OUT[15] CLK2 OUT[10]
+ OUT[8] OUT[1] OUT[11] OUT[2] OUT[14] VSS OUT[3] switch-matrix-16x1
Xswitch-matrix-16x1_0 OUT[4] OUT[9] OUT[13] VDD RSTN CLK1 IN[6] switch-matrix-16x1_0/Q
+ switch-matrix-16x1_1/Q OUT[6] OUT[7] OUT[0] OUT[12] OUT[5] OUT[15] CLK2 OUT[10]
+ OUT[8] OUT[1] OUT[11] OUT[2] OUT[14] VSS OUT[3] switch-matrix-16x1
Xswitch-matrix-16x1_73 OUT[4] OUT[9] OUT[13] VDD RSTN CLK1 IN[3] switch-matrix-16x1_73/Q
+ switch-matrix-16x1_74/Q OUT[6] OUT[7] OUT[0] OUT[12] OUT[5] OUT[15] CLK2 OUT[10]
+ OUT[8] OUT[1] OUT[11] OUT[2] OUT[14] VSS OUT[3] switch-matrix-16x1
Xswitch-matrix-16x1_63 OUT[4] OUT[9] OUT[13] VDD RSTN CLK1 IN[72] switch-matrix-16x1_64/D
+ switch-matrix-16x1_63/D OUT[6] OUT[7] OUT[0] OUT[12] OUT[5] OUT[15] CLK2 OUT[10]
+ OUT[8] OUT[1] OUT[11] OUT[2] OUT[14] VSS OUT[3] switch-matrix-16x1
Xswitch-matrix-16x1_52 OUT[4] OUT[9] OUT[13] VDD RSTN CLK1 IN[58] switch-matrix-16x1_52/Q
+ switch-matrix-16x1_53/Q OUT[6] OUT[7] OUT[0] OUT[12] OUT[5] OUT[15] CLK2 OUT[10]
+ OUT[8] OUT[1] OUT[11] OUT[2] OUT[14] VSS OUT[3] switch-matrix-16x1
Xswitch-matrix-16x1_41 OUT[4] OUT[9] OUT[13] VDD RSTN CLK1 IN[54] switch-matrix-16x1_42/D
+ switch-matrix-16x1_41/D OUT[6] OUT[7] OUT[0] OUT[12] OUT[5] OUT[15] CLK2 OUT[10]
+ OUT[8] OUT[1] OUT[11] OUT[2] OUT[14] VSS OUT[3] switch-matrix-16x1
Xswitch-matrix-16x1_30 OUT[4] OUT[9] OUT[13] VDD RSTN CLK1 IN[36] switch-matrix-16x1_30/Q
+ switch-matrix-16x1_31/Q OUT[6] OUT[7] OUT[0] OUT[12] OUT[5] OUT[15] CLK2 OUT[10]
+ OUT[8] OUT[1] OUT[11] OUT[2] OUT[14] VSS OUT[3] switch-matrix-16x1
Xswitch-matrix-16x1_1 OUT[4] OUT[9] OUT[13] VDD RSTN CLK1 IN[7] switch-matrix-16x1_1/Q
+ switch-matrix-16x1_2/Q OUT[6] OUT[7] OUT[0] OUT[12] OUT[5] OUT[15] CLK2 OUT[10]
+ OUT[8] OUT[1] OUT[11] OUT[2] OUT[14] VSS OUT[3] switch-matrix-16x1
Xswitch-matrix-16x1_74 OUT[4] OUT[9] OUT[13] VDD RSTN CLK1 IN[4] switch-matrix-16x1_74/Q
+ switch-matrix-16x1_75/Q OUT[6] OUT[7] OUT[0] OUT[12] OUT[5] OUT[15] CLK2 OUT[10]
+ OUT[8] OUT[1] OUT[11] OUT[2] OUT[14] VSS OUT[3] switch-matrix-16x1
Xswitch-matrix-16x1_64 OUT[4] OUT[9] OUT[13] VDD RSTN CLK1 IN[71] switch-matrix-16x1_65/D
+ switch-matrix-16x1_64/D OUT[6] OUT[7] OUT[0] OUT[12] OUT[5] OUT[15] CLK2 OUT[10]
+ OUT[8] OUT[1] OUT[11] OUT[2] OUT[14] VSS OUT[3] switch-matrix-16x1
Xswitch-matrix-16x1_53 OUT[4] OUT[9] OUT[13] VDD RSTN CLK1 IN[59] switch-matrix-16x1_53/Q
+ switch-matrix-16x1_54/Q OUT[6] OUT[7] OUT[0] OUT[12] OUT[5] OUT[15] CLK2 OUT[10]
+ OUT[8] OUT[1] OUT[11] OUT[2] OUT[14] VSS OUT[3] switch-matrix-16x1
Xswitch-matrix-16x1_42 OUT[4] OUT[9] OUT[13] VDD RSTN CLK1 IN[53] switch-matrix-16x1_43/D
+ switch-matrix-16x1_42/D OUT[6] OUT[7] OUT[0] OUT[12] OUT[5] OUT[15] CLK2 OUT[10]
+ OUT[8] OUT[1] OUT[11] OUT[2] OUT[14] VSS OUT[3] switch-matrix-16x1
Xswitch-matrix-16x1_31 OUT[4] OUT[9] OUT[13] VDD RSTN CLK1 IN[37] switch-matrix-16x1_31/Q
+ switch-matrix-16x1_32/Q OUT[6] OUT[7] OUT[0] OUT[12] OUT[5] OUT[15] CLK2 OUT[10]
+ OUT[8] OUT[1] OUT[11] OUT[2] OUT[14] VSS OUT[3] switch-matrix-16x1
Xswitch-matrix-16x1_20 OUT[4] OUT[9] OUT[13] VDD RSTN CLK1 IN[31] switch-matrix-16x1_25/D
+ switch-matrix-16x1_21/Q OUT[6] OUT[7] OUT[0] OUT[12] OUT[5] OUT[15] CLK2 OUT[10]
+ OUT[8] OUT[1] OUT[11] OUT[2] OUT[14] VSS OUT[3] switch-matrix-16x1
Xswitch-matrix-16x1_2 OUT[4] OUT[9] OUT[13] VDD RSTN CLK1 IN[8] switch-matrix-16x1_2/Q
+ switch-matrix-16x1_3/Q OUT[6] OUT[7] OUT[0] OUT[12] OUT[5] OUT[15] CLK2 OUT[10]
+ OUT[8] OUT[1] OUT[11] OUT[2] OUT[14] VSS OUT[3] switch-matrix-16x1
Xswitch-matrix-16x1_75 OUT[4] OUT[9] OUT[13] VDD RSTN CLK1 IN[5] switch-matrix-16x1_75/Q
+ switch-matrix-16x1_0/Q OUT[6] OUT[7] OUT[0] OUT[12] OUT[5] OUT[15] CLK2 OUT[10]
+ OUT[8] OUT[1] OUT[11] OUT[2] OUT[14] VSS OUT[3] switch-matrix-16x1
Xswitch-matrix-16x1_65 OUT[4] OUT[9] OUT[13] VDD RSTN CLK1 IN[70] switch-matrix-16x1_66/D
+ switch-matrix-16x1_65/D OUT[6] OUT[7] OUT[0] OUT[12] OUT[5] OUT[15] CLK2 OUT[10]
+ OUT[8] OUT[1] OUT[11] OUT[2] OUT[14] VSS OUT[3] switch-matrix-16x1
Xswitch-matrix-16x1_54 OUT[4] OUT[9] OUT[13] VDD RSTN CLK1 IN[60] switch-matrix-16x1_54/Q
+ switch-matrix-16x1_59/Q OUT[6] OUT[7] OUT[0] OUT[12] OUT[5] OUT[15] CLK2 OUT[10]
+ OUT[8] OUT[1] OUT[11] OUT[2] OUT[14] VSS OUT[3] switch-matrix-16x1
Xswitch-matrix-16x1_43 OUT[4] OUT[9] OUT[13] VDD RSTN CLK1 IN[52] switch-matrix-16x1_44/D
+ switch-matrix-16x1_43/D OUT[6] OUT[7] OUT[0] OUT[12] OUT[5] OUT[15] CLK2 OUT[10]
+ OUT[8] OUT[1] OUT[11] OUT[2] OUT[14] VSS OUT[3] switch-matrix-16x1
Xswitch-matrix-16x1_32 OUT[4] OUT[9] OUT[13] VDD RSTN CLK1 IN[38] switch-matrix-16x1_32/Q
+ switch-matrix-16x1_33/Q OUT[6] OUT[7] OUT[0] OUT[12] OUT[5] OUT[15] CLK2 OUT[10]
+ OUT[8] OUT[1] OUT[11] OUT[2] OUT[14] VSS OUT[3] switch-matrix-16x1
Xswitch-matrix-16x1_21 OUT[4] OUT[9] OUT[13] VDD RSTN CLK1 IN[32] switch-matrix-16x1_21/Q
+ switch-matrix-16x1_22/Q OUT[6] OUT[7] OUT[0] OUT[12] OUT[5] OUT[15] CLK2 OUT[10]
+ OUT[8] OUT[1] OUT[11] OUT[2] OUT[14] VSS OUT[3] switch-matrix-16x1
Xswitch-matrix-16x1_10 OUT[4] OUT[9] OUT[13] VDD RSTN CLK1 IN[17] switch-matrix-16x1_11/D
+ switch-matrix-16x1_12/Q OUT[6] OUT[7] OUT[0] OUT[12] OUT[5] OUT[15] CLK2 OUT[10]
+ OUT[8] OUT[1] OUT[11] OUT[2] OUT[14] VSS OUT[3] switch-matrix-16x1
Xswitch-matrix-16x1_3 OUT[4] OUT[9] OUT[13] VDD RSTN CLK1 IN[9] switch-matrix-16x1_3/Q
+ switch-matrix-16x1_4/Q OUT[6] OUT[7] OUT[0] OUT[12] OUT[5] OUT[15] CLK2 OUT[10]
+ OUT[8] OUT[1] OUT[11] OUT[2] OUT[14] VSS OUT[3] switch-matrix-16x1
Xswitch-matrix-16x1_66 OUT[4] OUT[9] OUT[13] VDD RSTN CLK1 IN[69] switch-matrix-16x1_67/D
+ switch-matrix-16x1_66/D OUT[6] OUT[7] OUT[0] OUT[12] OUT[5] OUT[15] CLK2 OUT[10]
+ OUT[8] OUT[1] OUT[11] OUT[2] OUT[14] VSS OUT[3] switch-matrix-16x1
Xswitch-matrix-16x1_55 OUT[4] OUT[9] OUT[13] VDD RSTN CLK1 IN[65] switch-matrix-16x1_56/D
+ switch-matrix-16x1_69/Q OUT[6] OUT[7] OUT[0] OUT[12] OUT[5] OUT[15] CLK2 OUT[10]
+ OUT[8] OUT[1] OUT[11] OUT[2] OUT[14] VSS OUT[3] switch-matrix-16x1
Xswitch-matrix-16x1_44 OUT[4] OUT[9] OUT[13] VDD RSTN CLK1 IN[51] switch-matrix-16x1_45/D
+ switch-matrix-16x1_44/D OUT[6] OUT[7] OUT[0] OUT[12] OUT[5] OUT[15] CLK2 OUT[10]
+ OUT[8] OUT[1] OUT[11] OUT[2] OUT[14] VSS OUT[3] switch-matrix-16x1
Xswitch-matrix-16x1_33 OUT[4] OUT[9] OUT[13] VDD RSTN CLK1 IN[39] switch-matrix-16x1_33/Q
+ switch-matrix-16x1_34/Q OUT[6] OUT[7] OUT[0] OUT[12] OUT[5] OUT[15] CLK2 OUT[10]
+ OUT[8] OUT[1] OUT[11] OUT[2] OUT[14] VSS OUT[3] switch-matrix-16x1
Xswitch-matrix-16x1_22 OUT[4] OUT[9] OUT[13] VDD RSTN CLK1 IN[33] switch-matrix-16x1_22/Q
+ switch-matrix-16x1_23/Q OUT[6] OUT[7] OUT[0] OUT[12] OUT[5] OUT[15] CLK2 OUT[10]
+ OUT[8] OUT[1] OUT[11] OUT[2] OUT[14] VSS OUT[3] switch-matrix-16x1
Xswitch-matrix-16x1_11 OUT[4] OUT[9] OUT[13] VDD RSTN CLK1 IN[16] switch-matrix-16x1_5/D
+ switch-matrix-16x1_11/D OUT[6] OUT[7] OUT[0] OUT[12] OUT[5] OUT[15] CLK2 OUT[10]
+ OUT[8] OUT[1] OUT[11] OUT[2] OUT[14] VSS OUT[3] switch-matrix-16x1
Xswitch-matrix-16x1_5 OUT[4] OUT[9] OUT[13] VDD RSTN CLK1 IN[15] switch-matrix-16x1_6/D
+ switch-matrix-16x1_5/D OUT[6] OUT[7] OUT[0] OUT[12] OUT[5] OUT[15] CLK2 OUT[10]
+ OUT[8] OUT[1] OUT[11] OUT[2] OUT[14] VSS OUT[3] switch-matrix-16x1
Xswitch-matrix-16x1_4 OUT[4] OUT[9] OUT[13] VDD RSTN CLK1 IN[10] switch-matrix-16x1_4/Q
+ switch-matrix-16x1_9/Q OUT[6] OUT[7] OUT[0] OUT[12] OUT[5] OUT[15] CLK2 OUT[10]
+ OUT[8] OUT[1] OUT[11] OUT[2] OUT[14] VSS OUT[3] switch-matrix-16x1
Xswitch-matrix-16x1_67 OUT[4] OUT[9] OUT[13] VDD RSTN CLK1 IN[68] switch-matrix-16x1_68/D
+ switch-matrix-16x1_67/D OUT[6] OUT[7] OUT[0] OUT[12] OUT[5] OUT[15] CLK2 OUT[10]
+ OUT[8] OUT[1] OUT[11] OUT[2] OUT[14] VSS OUT[3] switch-matrix-16x1
Xswitch-matrix-16x1_56 OUT[4] OUT[9] OUT[13] VDD RSTN CLK1 IN[64] switch-matrix-16x1_57/D
+ switch-matrix-16x1_56/D OUT[6] OUT[7] OUT[0] OUT[12] OUT[5] OUT[15] CLK2 OUT[10]
+ OUT[8] OUT[1] OUT[11] OUT[2] OUT[14] VSS OUT[3] switch-matrix-16x1
Xswitch-matrix-16x1_45 OUT[4] OUT[9] OUT[13] VDD RSTN CLK1 IN[50] switch-matrix-16x1_46/D
+ switch-matrix-16x1_45/D OUT[6] OUT[7] OUT[0] OUT[12] OUT[5] OUT[15] CLK2 OUT[10]
+ OUT[8] OUT[1] OUT[11] OUT[2] OUT[14] VSS OUT[3] switch-matrix-16x1
Xswitch-matrix-16x1_34 OUT[4] OUT[9] OUT[13] VDD RSTN CLK1 IN[40] switch-matrix-16x1_34/Q
+ switch-matrix-16x1_39/Q OUT[6] OUT[7] OUT[0] OUT[12] OUT[5] OUT[15] CLK2 OUT[10]
+ OUT[8] OUT[1] OUT[11] OUT[2] OUT[14] VSS OUT[3] switch-matrix-16x1
Xswitch-matrix-16x1_23 OUT[4] OUT[9] OUT[13] VDD RSTN CLK1 IN[34] switch-matrix-16x1_23/Q
+ switch-matrix-16x1_24/Q OUT[6] OUT[7] OUT[0] OUT[12] OUT[5] OUT[15] CLK2 OUT[10]
+ OUT[8] OUT[1] OUT[11] OUT[2] OUT[14] VSS OUT[3] switch-matrix-16x1
Xswitch-matrix-16x1_12 OUT[4] OUT[9] OUT[13] VDD RSTN CLK1 IN[18] switch-matrix-16x1_12/Q
+ switch-matrix-16x1_13/Q OUT[6] OUT[7] OUT[0] OUT[12] OUT[5] OUT[15] CLK2 OUT[10]
+ OUT[8] OUT[1] OUT[11] OUT[2] OUT[14] VSS OUT[3] switch-matrix-16x1
Xswitch-matrix-16x1_6 OUT[4] OUT[9] OUT[13] VDD RSTN CLK1 IN[14] switch-matrix-16x1_7/D
+ switch-matrix-16x1_6/D OUT[6] OUT[7] OUT[0] OUT[12] OUT[5] OUT[15] CLK2 OUT[10]
+ OUT[8] OUT[1] OUT[11] OUT[2] OUT[14] VSS OUT[3] switch-matrix-16x1
Xswitch-matrix-16x1_68 OUT[4] OUT[9] OUT[13] VDD RSTN CLK1 IN[67] switch-matrix-16x1_69/D
+ switch-matrix-16x1_68/D OUT[6] OUT[7] OUT[0] OUT[12] OUT[5] OUT[15] CLK2 OUT[10]
+ OUT[8] OUT[1] OUT[11] OUT[2] OUT[14] VSS OUT[3] switch-matrix-16x1
Xswitch-matrix-16x1_57 OUT[4] OUT[9] OUT[13] VDD RSTN CLK1 IN[63] switch-matrix-16x1_58/D
+ switch-matrix-16x1_57/D OUT[6] OUT[7] OUT[0] OUT[12] OUT[5] OUT[15] CLK2 OUT[10]
+ OUT[8] OUT[1] OUT[11] OUT[2] OUT[14] VSS OUT[3] switch-matrix-16x1
Xswitch-matrix-16x1_46 OUT[4] OUT[9] OUT[13] VDD RSTN CLK1 IN[49] switch-matrix-16x1_47/D
+ switch-matrix-16x1_46/D OUT[6] OUT[7] OUT[0] OUT[12] OUT[5] OUT[15] CLK2 OUT[10]
+ OUT[8] OUT[1] OUT[11] OUT[2] OUT[14] VSS OUT[3] switch-matrix-16x1
Xswitch-matrix-16x1_35 OUT[4] OUT[9] OUT[13] VDD RSTN CLK1 IN[45] switch-matrix-16x1_36/D
+ switch-matrix-16x1_49/Q OUT[6] OUT[7] OUT[0] OUT[12] OUT[5] OUT[15] CLK2 OUT[10]
+ OUT[8] OUT[1] OUT[11] OUT[2] OUT[14] VSS OUT[3] switch-matrix-16x1
Xswitch-matrix-16x1_24 OUT[4] OUT[9] OUT[13] VDD RSTN CLK1 IN[35] switch-matrix-16x1_24/Q
+ switch-matrix-16x1_30/Q OUT[6] OUT[7] OUT[0] OUT[12] OUT[5] OUT[15] CLK2 OUT[10]
+ OUT[8] OUT[1] OUT[11] OUT[2] OUT[14] VSS OUT[3] switch-matrix-16x1
Xswitch-matrix-16x1_13 OUT[4] OUT[9] OUT[13] VDD RSTN CLK1 IN[19] switch-matrix-16x1_13/Q
+ switch-matrix-16x1_14/Q OUT[6] OUT[7] OUT[0] OUT[12] OUT[5] OUT[15] CLK2 OUT[10]
+ OUT[8] OUT[1] OUT[11] OUT[2] OUT[14] VSS OUT[3] switch-matrix-16x1
Xswitch-matrix-16x1_7 OUT[4] OUT[9] OUT[13] VDD RSTN CLK1 IN[13] switch-matrix-16x1_8/D
+ switch-matrix-16x1_7/D OUT[6] OUT[7] OUT[0] OUT[12] OUT[5] OUT[15] CLK2 OUT[10]
+ OUT[8] OUT[1] OUT[11] OUT[2] OUT[14] VSS OUT[3] switch-matrix-16x1
Xswitch-matrix-16x1_69 OUT[4] OUT[9] OUT[13] VDD RSTN CLK1 IN[66] switch-matrix-16x1_69/Q
+ switch-matrix-16x1_69/D OUT[6] OUT[7] OUT[0] OUT[12] OUT[5] OUT[15] CLK2 OUT[10]
+ OUT[8] OUT[1] OUT[11] OUT[2] OUT[14] VSS OUT[3] switch-matrix-16x1
Xswitch-matrix-16x1_58 OUT[4] OUT[9] OUT[13] VDD RSTN CLK1 IN[62] switch-matrix-16x1_59/D
+ switch-matrix-16x1_58/D OUT[6] OUT[7] OUT[0] OUT[12] OUT[5] OUT[15] CLK2 OUT[10]
+ OUT[8] OUT[1] OUT[11] OUT[2] OUT[14] VSS OUT[3] switch-matrix-16x1
Xswitch-matrix-16x1_59 OUT[4] OUT[9] OUT[13] VDD RSTN CLK1 IN[61] switch-matrix-16x1_59/Q
+ switch-matrix-16x1_59/D OUT[6] OUT[7] OUT[0] OUT[12] OUT[5] OUT[15] CLK2 OUT[10]
+ OUT[8] OUT[1] OUT[11] OUT[2] OUT[14] VSS OUT[3] switch-matrix-16x1
Xswitch-matrix-16x1_47 OUT[4] OUT[9] OUT[13] VDD RSTN CLK1 IN[48] switch-matrix-16x1_48/D
+ switch-matrix-16x1_47/D OUT[6] OUT[7] OUT[0] OUT[12] OUT[5] OUT[15] CLK2 OUT[10]
+ OUT[8] OUT[1] OUT[11] OUT[2] OUT[14] VSS OUT[3] switch-matrix-16x1
Xswitch-matrix-16x1_48 OUT[4] OUT[9] OUT[13] VDD RSTN CLK1 IN[47] switch-matrix-16x1_49/D
+ switch-matrix-16x1_48/D OUT[6] OUT[7] OUT[0] OUT[12] OUT[5] OUT[15] CLK2 OUT[10]
+ OUT[8] OUT[1] OUT[11] OUT[2] OUT[14] VSS OUT[3] switch-matrix-16x1
Xswitch-matrix-16x1_36 OUT[4] OUT[9] OUT[13] VDD RSTN CLK1 IN[44] switch-matrix-16x1_37/D
+ switch-matrix-16x1_36/D OUT[6] OUT[7] OUT[0] OUT[12] OUT[5] OUT[15] CLK2 OUT[10]
+ OUT[8] OUT[1] OUT[11] OUT[2] OUT[14] VSS OUT[3] switch-matrix-16x1
Xswitch-matrix-16x1_37 OUT[4] OUT[9] OUT[13] VDD RSTN CLK1 IN[43] switch-matrix-16x1_38/D
+ switch-matrix-16x1_37/D OUT[6] OUT[7] OUT[0] OUT[12] OUT[5] OUT[15] CLK2 OUT[10]
+ OUT[8] OUT[1] OUT[11] OUT[2] OUT[14] VSS OUT[3] switch-matrix-16x1
Xswitch-matrix-16x1_25 OUT[4] OUT[9] OUT[13] VDD RSTN CLK1 IN[30] switch-matrix-16x1_26/D
+ switch-matrix-16x1_25/D OUT[6] OUT[7] OUT[0] OUT[12] OUT[5] OUT[15] CLK2 OUT[10]
+ OUT[8] OUT[1] OUT[11] OUT[2] OUT[14] VSS OUT[3] switch-matrix-16x1
Xswitch-matrix-16x1_26 OUT[4] OUT[9] OUT[13] VDD RSTN CLK1 IN[29] switch-matrix-16x1_27/D
+ switch-matrix-16x1_26/D OUT[6] OUT[7] OUT[0] OUT[12] OUT[5] OUT[15] CLK2 OUT[10]
+ OUT[8] OUT[1] OUT[11] OUT[2] OUT[14] VSS OUT[3] switch-matrix-16x1
Xswitch-matrix-16x1_15 OUT[4] OUT[9] OUT[13] VDD RSTN CLK1 IN[21] switch-matrix-16x1_15/Q
+ switch-matrix-16x1_16/Q OUT[6] OUT[7] OUT[0] OUT[12] OUT[5] OUT[15] CLK2 OUT[10]
+ OUT[8] OUT[1] OUT[11] OUT[2] OUT[14] VSS OUT[3] switch-matrix-16x1
Xswitch-matrix-16x1_14 OUT[4] OUT[9] OUT[13] VDD RSTN CLK1 IN[20] switch-matrix-16x1_14/Q
+ switch-matrix-16x1_15/Q OUT[6] OUT[7] OUT[0] OUT[12] OUT[5] OUT[15] CLK2 OUT[10]
+ OUT[8] OUT[1] OUT[11] OUT[2] OUT[14] VSS OUT[3] switch-matrix-16x1
Xswitch-matrix-16x1_8 OUT[4] OUT[9] OUT[13] VDD RSTN CLK1 IN[12] switch-matrix-16x1_9/D
+ switch-matrix-16x1_8/D OUT[6] OUT[7] OUT[0] OUT[12] OUT[5] OUT[15] CLK2 OUT[10]
+ OUT[8] OUT[1] OUT[11] OUT[2] OUT[14] VSS OUT[3] switch-matrix-16x1
Xswitch-matrix-16x1_49 OUT[4] OUT[9] OUT[13] VDD RSTN CLK1 IN[46] switch-matrix-16x1_49/Q
+ switch-matrix-16x1_49/D OUT[6] OUT[7] OUT[0] OUT[12] OUT[5] OUT[15] CLK2 OUT[10]
+ OUT[8] OUT[1] OUT[11] OUT[2] OUT[14] VSS OUT[3] switch-matrix-16x1
Xswitch-matrix-16x1_38 OUT[4] OUT[9] OUT[13] VDD RSTN CLK1 IN[42] switch-matrix-16x1_39/D
+ switch-matrix-16x1_38/D OUT[6] OUT[7] OUT[0] OUT[12] OUT[5] OUT[15] CLK2 OUT[10]
+ OUT[8] OUT[1] OUT[11] OUT[2] OUT[14] VSS OUT[3] switch-matrix-16x1
Xswitch-matrix-16x1_27 OUT[4] OUT[9] OUT[13] VDD RSTN CLK1 IN[28] switch-matrix-16x1_28/D
+ switch-matrix-16x1_27/D OUT[6] OUT[7] OUT[0] OUT[12] OUT[5] OUT[15] CLK2 OUT[10]
+ OUT[8] OUT[1] OUT[11] OUT[2] OUT[14] VSS OUT[3] switch-matrix-16x1
Xswitch-matrix-16x1_16 OUT[4] OUT[9] OUT[13] VDD RSTN CLK1 IN[22] switch-matrix-16x1_16/Q
+ switch-matrix-16x1_17/Q OUT[6] OUT[7] OUT[0] OUT[12] OUT[5] OUT[15] CLK2 OUT[10]
+ OUT[8] OUT[1] OUT[11] OUT[2] OUT[14] VSS OUT[3] switch-matrix-16x1
Xswitch-matrix-16x1_9 OUT[4] OUT[9] OUT[13] VDD RSTN CLK1 IN[11] switch-matrix-16x1_9/Q
+ switch-matrix-16x1_9/D OUT[6] OUT[7] OUT[0] OUT[12] OUT[5] OUT[15] CLK2 OUT[10]
+ OUT[8] OUT[1] OUT[11] OUT[2] OUT[14] VSS OUT[3] switch-matrix-16x1
Xswitch-matrix-16x1_39 OUT[4] OUT[9] OUT[13] VDD RSTN CLK1 IN[41] switch-matrix-16x1_39/Q
+ switch-matrix-16x1_39/D OUT[6] OUT[7] OUT[0] OUT[12] OUT[5] OUT[15] CLK2 OUT[10]
+ OUT[8] OUT[1] OUT[11] OUT[2] OUT[14] VSS OUT[3] switch-matrix-16x1
Xswitch-matrix-16x1_28 OUT[4] OUT[9] OUT[13] VDD RSTN CLK1 IN[27] switch-matrix-16x1_29/D
+ switch-matrix-16x1_28/D OUT[6] OUT[7] OUT[0] OUT[12] OUT[5] OUT[15] CLK2 OUT[10]
+ OUT[8] OUT[1] OUT[11] OUT[2] OUT[14] VSS OUT[3] switch-matrix-16x1
Xswitch-matrix-16x1_17 OUT[4] OUT[9] OUT[13] VDD RSTN CLK1 IN[23] switch-matrix-16x1_17/Q
+ switch-matrix-16x1_18/Q OUT[6] OUT[7] OUT[0] OUT[12] OUT[5] OUT[15] CLK2 OUT[10]
+ OUT[8] OUT[1] OUT[11] OUT[2] OUT[14] VSS OUT[3] switch-matrix-16x1
Xswitch-matrix-16x1_29 OUT[4] OUT[9] OUT[13] VDD RSTN CLK1 IN[26] switch-matrix-16x1_29/Q
+ switch-matrix-16x1_29/D OUT[6] OUT[7] OUT[0] OUT[12] OUT[5] OUT[15] CLK2 OUT[10]
+ OUT[8] OUT[1] OUT[11] OUT[2] OUT[14] VSS OUT[3] switch-matrix-16x1
Xswitch-matrix-16x1_18 OUT[4] OUT[9] OUT[13] VDD RSTN CLK1 IN[24] switch-matrix-16x1_18/Q
+ switch-matrix-16x1_19/Q OUT[6] OUT[7] OUT[0] OUT[12] OUT[5] OUT[15] CLK2 OUT[10]
+ OUT[8] OUT[1] OUT[11] OUT[2] OUT[14] VSS OUT[3] switch-matrix-16x1
Xswitch-matrix-16x1_19 OUT[4] OUT[9] OUT[13] VDD RSTN CLK1 IN[25] switch-matrix-16x1_19/Q
+ switch-matrix-16x1_29/Q OUT[6] OUT[7] OUT[0] OUT[12] OUT[5] OUT[15] CLK2 OUT[10]
+ OUT[8] OUT[1] OUT[11] OUT[2] OUT[14] VSS OUT[3] switch-matrix-16x1
.ends
