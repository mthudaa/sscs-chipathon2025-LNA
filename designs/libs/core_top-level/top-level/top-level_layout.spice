* NGSPICE file created from top-level.ext - technology: gf180mcuD

.subckt pfet_06v0_R6Z25Q a_162_n624# a_n162_n668# a_n250_n624# a_52_n668# w_n426_n832#
+ a_n52_n624#
X0 a_n52_n624# a_n162_n668# a_n250_n624# w_n426_n832# pfet_06v0 ad=1.56p pd=6.52u as=2.64p ps=12.88u w=6u l=0.55u
X1 a_162_n624# a_52_n668# a_n52_n624# w_n426_n832# pfet_06v0 ad=2.64p pd=12.88u as=1.56p ps=6.52u w=6u l=0.55u
.ends

.subckt pfet_06v0_ZXY25Q a_162_n624# a_n162_n668# a_n266_n624# w_n640_n832# a_52_n668#
+ a_376_n624# a_n376_n668# a_n464_n624# a_266_n668# a_n52_n624#
X0 a_376_n624# a_266_n668# a_162_n624# w_n640_n832# pfet_06v0 ad=2.64p pd=12.88u as=1.56p ps=6.52u w=6u l=0.55u
X1 a_n52_n624# a_n162_n668# a_n266_n624# w_n640_n832# pfet_06v0 ad=1.56p pd=6.52u as=1.56p ps=6.52u w=6u l=0.55u
X2 a_162_n624# a_52_n668# a_n52_n624# w_n640_n832# pfet_06v0 ad=1.56p pd=6.52u as=1.56p ps=6.52u w=6u l=0.55u
X3 a_n266_n624# a_n376_n668# a_n464_n624# w_n640_n832# pfet_06v0 ad=1.56p pd=6.52u as=2.64p ps=12.88u w=6u l=0.55u
.ends

.subckt pfet-com G1 D1 G2 D2 G3 D3 G4 D4 VDD
Xpfet_06v0_R6Z25Q_0 D2 G2 D2 G2 VDD VDD pfet_06v0_R6Z25Q
XM11 VDD G3 VDD VDD G3 D3 G3 D3 G3 D3 pfet_06v0_ZXY25Q
XM9 D1 G1 D1 G1 VDD VDD pfet_06v0_R6Z25Q
Xpfet_06v0_ZXY25Q_0 VDD G4 VDD VDD G4 D4 G4 D4 G4 D4 pfet_06v0_ZXY25Q
.ends

.subckt nfet_06v0_52FGQA a_n524_n174# a_n296_n174# a_n436_n218# a_n52_n174# a_n192_n218#
+ a_296_n218# a_436_n174# a_n668_n350# a_192_n174# a_52_n218#
X0 a_436_n174# a_296_n218# a_192_n174# a_n668_n350# nfet_06v0 ad=0.66p pd=3.88u as=0.39p ps=2.02u w=1.5u l=0.7u
X1 a_192_n174# a_52_n218# a_n52_n174# a_n668_n350# nfet_06v0 ad=0.39p pd=2.02u as=0.39p ps=2.02u w=1.5u l=0.7u
X2 a_n52_n174# a_n192_n218# a_n296_n174# a_n668_n350# nfet_06v0 ad=0.39p pd=2.02u as=0.39p ps=2.02u w=1.5u l=0.7u
X3 a_n296_n174# a_n436_n218# a_n524_n174# a_n668_n350# nfet_06v0 ad=0.39p pd=2.02u as=0.66p ps=3.88u w=1.5u l=0.7u
.ends

.subckt nfet-pin G1 D1 S1 G2 D2 S2 B
Xnfet_06v0_52FGQA_0 S1 D1 G1 S1 G1 G1 S1 B D1 G1 nfet_06v0_52FGQA
XM17 S2 D2 G2 S2 G2 G2 S2 B D2 G2 nfet_06v0_52FGQA
.ends

.subckt pfet-vdd VDD G1 D1 S1 G2 D2 S2
XM1 D1 G1 D1 VDD G1 S1 G1 S1 G1 S1 pfet_06v0_ZXY25Q
Xpfet_06v0_ZXY25Q_0 D2 G2 D2 VDD G2 S2 G2 S2 G2 S2 pfet_06v0_ZXY25Q
.ends

.subckt pfet_06v0_CA9BXH a_n452_n432# a_n556_n376# w_n1220_n632# a_956_n376# a_52_n432#
+ a_n1044_n376# a_n956_n432# a_556_n432# a_n52_n376# a_452_n376#
X0 a_n556_n376# a_n956_n432# a_n1044_n376# w_n1220_n632# pfet_06v0 ad=1.04p pd=4.52u as=1.76p ps=8.88u w=4u l=2u
X1 a_n52_n376# a_n452_n432# a_n556_n376# w_n1220_n632# pfet_06v0 ad=1.04p pd=4.52u as=1.04p ps=4.52u w=4u l=2u
X2 a_452_n376# a_52_n432# a_n52_n376# w_n1220_n632# pfet_06v0 ad=1.04p pd=4.52u as=1.04p ps=4.52u w=4u l=2u
X3 a_956_n376# a_556_n432# a_452_n376# w_n1220_n632# pfet_06v0 ad=1.76p pd=8.88u as=1.04p ps=4.52u w=4u l=2u
.ends

.subckt cap_mim_2p0fF_BZM3VC m4_n620_n500# m4_n740_n620#
X0 m4_n620_n500# m4_n740_n620# cap_mim_2f0_m4m5_noshield c_width=5u c_length=5u
.ends

.subckt nfet_06v0_9CQTU4 a_52_n468# a_956_n424# a_n1044_n424# a_n956_n468# a_556_n468#
+ a_n52_n424# a_452_n424# a_n452_n468# a_n556_n424# a_n1188_n600#
X0 a_452_n424# a_52_n468# a_n52_n424# a_n1188_n600# nfet_06v0 ad=1.04p pd=4.52u as=1.04p ps=4.52u w=4u l=2u
X1 a_956_n424# a_556_n468# a_452_n424# a_n1188_n600# nfet_06v0 ad=1.76p pd=8.88u as=1.04p ps=4.52u w=4u l=2u
X2 a_n556_n424# a_n956_n468# a_n1044_n424# a_n1188_n600# nfet_06v0 ad=1.04p pd=4.52u as=1.76p ps=8.88u w=4u l=2u
X3 a_n52_n424# a_n452_n468# a_n556_n424# a_n1188_n600# nfet_06v0 ad=1.04p pd=4.52u as=1.04p ps=4.52u w=4u l=2u
.ends

.subckt nfet_06v0_UAC3LK a_200_n424# a_n432_n600# a_n200_n468# a_n288_n424#
X0 a_200_n424# a_n200_n468# a_n288_n424# a_n432_n600# nfet_06v0 ad=1.76p pd=8.88u as=1.76p ps=8.88u w=4u l=2u
.ends

.subckt n-ota OUT VDD IBIAS VN VP VSS
Xpfet_06v0_CA9BXH_0 m1_1639_1477# m1_1639_1477# VDD VDD m1_1639_1477# VDD m1_1639_1477#
+ m1_1639_1477# VDD m1_2976_431# pfet_06v0_CA9BXH
Xpfet_06v0_CA9BXH_1 m1_2976_431# VDD VDD OUT m1_2976_431# OUT m1_2976_431# m1_2976_431#
+ OUT VDD pfet_06v0_CA9BXH
Xcap_mim_2p0fF_BZM3VC_0 OUT m1_2976_431# cap_mim_2p0fF_BZM3VC
XM2 VN m1_1454_132# m1_1454_132# VP VN m1_1454_132# m1_2976_431# VP m1_1639_1477#
+ VSS nfet_06v0_9CQTU4
Xnfet_06v0_UAC3LK_0 OUT VSS IBIAS VSS nfet_06v0_UAC3LK
XM4 m1_1454_132# VSS IBIAS VSS nfet_06v0_UAC3LK
.ends

.subckt pfet-pin G1 D1 S1 G2 D2 S2 B
XM1 D1 G1 D1 B G1 S1 G1 S1 G1 S1 pfet_06v0_ZXY25Q
Xpfet_06v0_ZXY25Q_0 D2 G2 D2 B G2 S2 G2 S2 G2 S2 pfet_06v0_ZXY25Q
.ends

.subckt gf180mcu_fd_sc_mcu9t5v0__nand2_1 A1 A2 ZN VDD VNW VPW VSS
X0 ZN A2 VDD VNW pfet_06v0 ad=0.4277p pd=2.165u as=0.7238p ps=4.17u w=1.645u l=0.5u
X1 VDD A1 ZN VNW pfet_06v0 ad=0.7238p pd=4.17u as=0.4277p ps=2.165u w=1.645u l=0.5u
X2 ZN A1 a_245_69# VPW nfet_06v0 ad=0.5808p pd=3.52u as=0.2112p ps=1.64u w=1.32u l=0.6u
X3 a_245_69# A2 VSS VPW nfet_06v0 ad=0.2112p pd=1.64u as=0.5808p ps=3.52u w=1.32u l=0.6u
.ends

.subckt gf180mcu_fd_sc_mcu9t5v0__inv_1 I ZN VDD VNW VPW VSS
X0 ZN I VDD VNW pfet_06v0 ad=0.8052p pd=4.54u as=0.8052p ps=4.54u w=1.83u l=0.5u
X1 ZN I VSS VPW nfet_06v0 ad=0.5808p pd=3.52u as=0.5808p ps=3.52u w=1.32u l=0.6u
.ends

.subckt NO_ClkGen CLK PHI_2 PHI_1 VDDd VSSd
Xgf180mcu_fd_sc_mcu9t5v0__nand2_1_0 gf180mcu_fd_sc_mcu9t5v0__inv_1_8/ZN gf180mcu_fd_sc_mcu9t5v0__inv_1_16/I
+ gf180mcu_fd_sc_mcu9t5v0__inv_1_0/I VDDd VDDd VSSd VSSd gf180mcu_fd_sc_mcu9t5v0__nand2_1
Xgf180mcu_fd_sc_mcu9t5v0__nand2_1_1 gf180mcu_fd_sc_mcu9t5v0__inv_1_7/ZN gf180mcu_fd_sc_mcu9t5v0__inv_1_16/ZN
+ gf180mcu_fd_sc_mcu9t5v0__inv_1_15/I VDDd VDDd VSSd VSSd gf180mcu_fd_sc_mcu9t5v0__nand2_1
Xgf180mcu_fd_sc_mcu9t5v0__inv_1_0 gf180mcu_fd_sc_mcu9t5v0__inv_1_0/I PHI_2 VDDd VDDd
+ VSSd VSSd gf180mcu_fd_sc_mcu9t5v0__inv_1
Xgf180mcu_fd_sc_mcu9t5v0__inv_1_2 gf180mcu_fd_sc_mcu9t5v0__inv_1_2/I gf180mcu_fd_sc_mcu9t5v0__inv_1_3/I
+ VDDd VDDd VSSd VSSd gf180mcu_fd_sc_mcu9t5v0__inv_1
Xgf180mcu_fd_sc_mcu9t5v0__inv_1_1 PHI_2 gf180mcu_fd_sc_mcu9t5v0__inv_1_2/I VDDd VDDd
+ VSSd VSSd gf180mcu_fd_sc_mcu9t5v0__inv_1
Xgf180mcu_fd_sc_mcu9t5v0__inv_1_3 gf180mcu_fd_sc_mcu9t5v0__inv_1_3/I gf180mcu_fd_sc_mcu9t5v0__inv_1_4/I
+ VDDd VDDd VSSd VSSd gf180mcu_fd_sc_mcu9t5v0__inv_1
Xgf180mcu_fd_sc_mcu9t5v0__inv_1_4 gf180mcu_fd_sc_mcu9t5v0__inv_1_4/I gf180mcu_fd_sc_mcu9t5v0__inv_1_5/I
+ VDDd VDDd VSSd VSSd gf180mcu_fd_sc_mcu9t5v0__inv_1
Xgf180mcu_fd_sc_mcu9t5v0__inv_1_5 gf180mcu_fd_sc_mcu9t5v0__inv_1_5/I gf180mcu_fd_sc_mcu9t5v0__inv_1_6/I
+ VDDd VDDd VSSd VSSd gf180mcu_fd_sc_mcu9t5v0__inv_1
Xgf180mcu_fd_sc_mcu9t5v0__inv_1_6 gf180mcu_fd_sc_mcu9t5v0__inv_1_6/I gf180mcu_fd_sc_mcu9t5v0__inv_1_7/I
+ VDDd VDDd VSSd VSSd gf180mcu_fd_sc_mcu9t5v0__inv_1
Xgf180mcu_fd_sc_mcu9t5v0__inv_1_7 gf180mcu_fd_sc_mcu9t5v0__inv_1_7/I gf180mcu_fd_sc_mcu9t5v0__inv_1_7/ZN
+ VDDd VDDd VSSd VSSd gf180mcu_fd_sc_mcu9t5v0__inv_1
Xgf180mcu_fd_sc_mcu9t5v0__inv_1_10 gf180mcu_fd_sc_mcu9t5v0__inv_1_10/I gf180mcu_fd_sc_mcu9t5v0__inv_1_9/I
+ VDDd VDDd VSSd VSSd gf180mcu_fd_sc_mcu9t5v0__inv_1
Xgf180mcu_fd_sc_mcu9t5v0__inv_1_8 gf180mcu_fd_sc_mcu9t5v0__inv_1_8/I gf180mcu_fd_sc_mcu9t5v0__inv_1_8/ZN
+ VDDd VDDd VSSd VSSd gf180mcu_fd_sc_mcu9t5v0__inv_1
Xgf180mcu_fd_sc_mcu9t5v0__inv_1_11 gf180mcu_fd_sc_mcu9t5v0__inv_1_11/I gf180mcu_fd_sc_mcu9t5v0__inv_1_10/I
+ VDDd VDDd VSSd VSSd gf180mcu_fd_sc_mcu9t5v0__inv_1
Xgf180mcu_fd_sc_mcu9t5v0__inv_1_9 gf180mcu_fd_sc_mcu9t5v0__inv_1_9/I gf180mcu_fd_sc_mcu9t5v0__inv_1_8/I
+ VDDd VDDd VSSd VSSd gf180mcu_fd_sc_mcu9t5v0__inv_1
Xgf180mcu_fd_sc_mcu9t5v0__inv_1_12 gf180mcu_fd_sc_mcu9t5v0__inv_1_12/I gf180mcu_fd_sc_mcu9t5v0__inv_1_11/I
+ VDDd VDDd VSSd VSSd gf180mcu_fd_sc_mcu9t5v0__inv_1
Xgf180mcu_fd_sc_mcu9t5v0__inv_1_13 gf180mcu_fd_sc_mcu9t5v0__inv_1_13/I gf180mcu_fd_sc_mcu9t5v0__inv_1_12/I
+ VDDd VDDd VSSd VSSd gf180mcu_fd_sc_mcu9t5v0__inv_1
Xgf180mcu_fd_sc_mcu9t5v0__inv_1_14 PHI_1 gf180mcu_fd_sc_mcu9t5v0__inv_1_13/I VDDd
+ VDDd VSSd VSSd gf180mcu_fd_sc_mcu9t5v0__inv_1
Xgf180mcu_fd_sc_mcu9t5v0__inv_1_15 gf180mcu_fd_sc_mcu9t5v0__inv_1_15/I PHI_1 VDDd
+ VDDd VSSd VSSd gf180mcu_fd_sc_mcu9t5v0__inv_1
Xgf180mcu_fd_sc_mcu9t5v0__inv_1_16 gf180mcu_fd_sc_mcu9t5v0__inv_1_16/I gf180mcu_fd_sc_mcu9t5v0__inv_1_16/ZN
+ VDDd VDDd VSSd VSSd gf180mcu_fd_sc_mcu9t5v0__inv_1
Xgf180mcu_fd_sc_mcu9t5v0__inv_1_17 CLK gf180mcu_fd_sc_mcu9t5v0__inv_1_16/I VDDd VDDd
+ VSSd VSSd gf180mcu_fd_sc_mcu9t5v0__inv_1
.ends

.subckt gf180mcu_fd_sc_mcu7t5v0__fillcap_4 VDD VNW VPW VSS
X0 a_124_375# a_36_472# VSS VPW nfet_06v0 ad=0.3608p pd=2.52u as=0.3608p ps=2.52u w=0.82u l=1u
X1 VDD a_124_375# a_36_472# VNW pfet_06v0 ad=0.5368p pd=3.32u as=0.5368p ps=3.32u w=1.22u l=1u
.ends

.subckt gf180mcu_fd_sc_mcu7t5v0__dffq_1 D CLK Q VDD VNW VPW VSS
X0 VSS CLK a_36_151# VPW nfet_06v0 ad=0.1053p pd=0.925u as=0.1782p ps=1.69u w=0.405u l=0.6u
X1 Q a_2304_115# VSS VPW nfet_06v0 ad=0.3608p pd=2.52u as=0.3608p ps=2.52u w=0.82u l=0.6u
X2 a_2304_115# a_2011_527# VSS VPW nfet_06v0 ad=0.176p pd=1.68u as=0.142p ps=1.14u w=0.4u l=0.6u
X3 a_1004_159# D a_836_159# VPW nfet_06v0 ad=0.207p pd=1.51u as=43.2f ps=0.6u w=0.36u l=0.6u
X4 a_1004_159# D a_880_527# VNW pfet_06v0 ad=0.1872p pd=1.4u as=54f ps=0.66u w=0.36u l=0.5u
X5 a_2011_527# a_36_151# a_1376_115# VNW pfet_06v0 ad=0.1665p pd=1.285u as=0.1791p ps=1.355u w=0.36u l=0.5u
X6 a_2296_527# a_448_472# a_2011_527# VNW pfet_06v0 ad=50.4f pd=0.64u as=0.1665p ps=1.285u w=0.36u l=0.5u
X7 a_1376_115# a_1004_159# VDD VNW pfet_06v0 ad=0.1791p pd=1.355u as=0.1044p ps=0.94u w=0.36u l=0.5u
X8 VDD CLK a_36_151# VNW pfet_06v0 ad=0.2249p pd=1.385u as=0.3806p ps=2.61u w=0.865u l=0.5u
X9 VSS a_1376_115# a_1328_159# VPW nfet_06v0 ad=0.2637p pd=1.825u as=43.2f ps=0.6u w=0.36u l=0.6u
X10 a_2011_527# a_448_472# a_1376_115# VPW nfet_06v0 ad=93.59999f pd=0.88u as=93.59999f ps=0.88u w=0.36u l=0.6u
X11 a_448_472# a_36_151# VDD VNW pfet_06v0 ad=0.3806p pd=2.61u as=0.2249p ps=1.385u w=0.865u l=0.5u
X12 Q a_2304_115# VDD VNW pfet_06v0 ad=0.5368p pd=3.32u as=0.5368p ps=3.32u w=1.22u l=0.5u
X13 a_1376_115# a_1004_159# VSS VPW nfet_06v0 ad=93.59999f pd=0.88u as=0.2637p ps=1.825u w=0.36u l=0.6u
X14 VSS a_2304_115# a_2256_159# VPW nfet_06v0 ad=0.142p pd=1.14u as=43.2f ps=0.6u w=0.36u l=0.6u
X15 a_836_159# a_36_151# VSS VPW nfet_06v0 ad=43.2f pd=0.6u as=0.1584p ps=1.6u w=0.36u l=0.6u
X16 a_448_472# a_36_151# VSS VPW nfet_06v0 ad=0.1782p pd=1.69u as=0.1053p ps=0.925u w=0.405u l=0.6u
X17 a_2256_159# a_36_151# a_2011_527# VPW nfet_06v0 ad=43.2f pd=0.6u as=93.59999f ps=0.88u w=0.36u l=0.6u
X18 a_880_527# a_448_472# VDD VNW pfet_06v0 ad=54f pd=0.66u as=0.4554p ps=3.25u w=0.36u l=0.5u
X19 a_1348_527# a_36_151# a_1004_159# VNW pfet_06v0 ad=43.2f pd=0.6u as=0.1872p ps=1.4u w=0.36u l=0.5u
X20 a_1328_159# a_448_472# a_1004_159# VPW nfet_06v0 ad=43.2f pd=0.6u as=0.207p ps=1.51u w=0.36u l=0.6u
X21 VDD a_1376_115# a_1348_527# VNW pfet_06v0 ad=0.1044p pd=0.94u as=43.2f ps=0.6u w=0.36u l=0.5u
X22 VDD a_2304_115# a_2296_527# VNW pfet_06v0 ad=0.23p pd=1.54u as=50.4f ps=0.64u w=0.36u l=0.5u
X23 a_2304_115# a_2011_527# VDD VNW pfet_06v0 ad=0.352p pd=2.48u as=0.23p ps=1.54u w=0.8u l=0.5u
.ends

.subckt gf180mcu_fd_sc_mcu7t5v0__fillcap_8 VDD VNW VPW VSS
X0 VDD a_572_375# a_484_472# VNW pfet_06v0 ad=0.5368p pd=3.32u as=0.5368p ps=3.32u w=1.22u l=1u
X1 a_572_375# a_484_472# VSS VPW nfet_06v0 ad=0.3608p pd=2.52u as=0.3608p ps=2.52u w=0.82u l=1u
X2 a_124_375# a_36_472# VSS VPW nfet_06v0 ad=0.3608p pd=2.52u as=0.3608p ps=2.52u w=0.82u l=1u
X3 VDD a_124_375# a_36_472# VNW pfet_06v0 ad=0.5368p pd=3.32u as=0.5368p ps=3.32u w=1.22u l=1u
.ends

.subckt gf180mcu_fd_sc_mcu7t5v0__dffq_4 D CLK Q VDD VNW VPW VSS
X0 VSS CLK a_36_151# VPW nfet_06v0 ad=0.1053p pd=0.925u as=0.1782p ps=1.69u w=0.405u l=0.6u
X1 VDD a_2011_527# a_2304_115# VNW pfet_06v0 ad=0.38575p pd=1.92u as=0.2457p ps=1.465u w=0.945u l=0.5u
X2 a_1004_159# D a_836_159# VPW nfet_06v0 ad=0.207p pd=1.51u as=43.2f ps=0.6u w=0.36u l=0.6u
X3 VSS a_2304_115# Q VPW nfet_06v0 ad=0.3586p pd=2.51u as=0.2119p ps=1.335u w=0.815u l=0.6u
X4 a_2304_115# a_2011_527# VSS VPW nfet_06v0 ad=0.2119p pd=1.335u as=0.2333p ps=1.555u w=0.815u l=0.6u
X5 a_1004_159# D a_880_527# VNW pfet_06v0 ad=0.1872p pd=1.4u as=54f ps=0.66u w=0.36u l=0.5u
X6 a_2011_527# a_36_151# a_1376_115# VNW pfet_06v0 ad=0.1665p pd=1.285u as=0.1791p ps=1.355u w=0.36u l=0.5u
X7 a_2296_527# a_448_472# a_2011_527# VNW pfet_06v0 ad=50.4f pd=0.64u as=0.1665p ps=1.285u w=0.36u l=0.5u
X8 Q a_2304_115# VDD VNW pfet_06v0 ad=0.4392p pd=1.94u as=0.38575p ps=1.92u w=1.22u l=0.5u
X9 VSS a_2304_115# Q VPW nfet_06v0 ad=0.2119p pd=1.335u as=0.2119p ps=1.335u w=0.815u l=0.6u
X10 a_1376_115# a_1004_159# VDD VNW pfet_06v0 ad=0.1791p pd=1.355u as=0.1044p ps=0.94u w=0.36u l=0.5u
X11 VDD CLK a_36_151# VNW pfet_06v0 ad=0.2249p pd=1.385u as=0.3806p ps=2.61u w=0.865u l=0.5u
X12 VDD a_2304_115# Q VNW pfet_06v0 ad=0.3172p pd=1.74u as=0.4392p ps=1.94u w=1.22u l=0.5u
X13 VSS a_1376_115# a_1328_159# VPW nfet_06v0 ad=0.2637p pd=1.825u as=43.2f ps=0.6u w=0.36u l=0.6u
X14 a_2011_527# a_448_472# a_1376_115# VPW nfet_06v0 ad=93.59999f pd=0.88u as=93.59999f ps=0.88u w=0.36u l=0.6u
X15 Q a_2304_115# VDD VNW pfet_06v0 ad=0.4392p pd=1.94u as=0.3172p ps=1.74u w=1.22u l=0.5u
X16 a_448_472# a_36_151# VDD VNW pfet_06v0 ad=0.3806p pd=2.61u as=0.2249p ps=1.385u w=0.865u l=0.5u
X17 Q a_2304_115# VSS VPW nfet_06v0 ad=0.2119p pd=1.335u as=0.2119p ps=1.335u w=0.815u l=0.6u
X18 a_1376_115# a_1004_159# VSS VPW nfet_06v0 ad=93.59999f pd=0.88u as=0.2637p ps=1.825u w=0.36u l=0.6u
X19 VSS a_2304_115# a_2256_159# VPW nfet_06v0 ad=0.2333p pd=1.555u as=43.2f ps=0.6u w=0.36u l=0.6u
X20 Q a_2304_115# VSS VPW nfet_06v0 ad=0.2119p pd=1.335u as=0.2608p ps=1.455u w=0.815u l=0.6u
X21 a_836_159# a_36_151# VSS VPW nfet_06v0 ad=43.2f pd=0.6u as=0.1584p ps=1.6u w=0.36u l=0.6u
X22 a_448_472# a_36_151# VSS VPW nfet_06v0 ad=0.1782p pd=1.69u as=0.1053p ps=0.925u w=0.405u l=0.6u
X23 a_2256_159# a_36_151# a_2011_527# VPW nfet_06v0 ad=43.2f pd=0.6u as=93.59999f ps=0.88u w=0.36u l=0.6u
X24 a_880_527# a_448_472# VDD VNW pfet_06v0 ad=54f pd=0.66u as=0.4554p ps=3.25u w=0.36u l=0.5u
X25 a_1348_527# a_36_151# a_1004_159# VNW pfet_06v0 ad=43.2f pd=0.6u as=0.1872p ps=1.4u w=0.36u l=0.5u
X26 VDD a_2304_115# Q VNW pfet_06v0 ad=0.5368p pd=3.32u as=0.4392p ps=1.94u w=1.22u l=0.5u
X27 a_1328_159# a_448_472# a_1004_159# VPW nfet_06v0 ad=43.2f pd=0.6u as=0.207p ps=1.51u w=0.36u l=0.6u
X28 VDD a_1376_115# a_1348_527# VNW pfet_06v0 ad=0.1044p pd=0.94u as=43.2f ps=0.6u w=0.36u l=0.5u
X29 VSS a_2011_527# a_2304_115# VPW nfet_06v0 ad=0.2608p pd=1.455u as=0.2119p ps=1.335u w=0.815u l=0.6u
X30 VDD a_2304_115# a_2296_527# VNW pfet_06v0 ad=0.2619p pd=1.685u as=50.4f ps=0.64u w=0.36u l=0.5u
X31 a_2304_115# a_2011_527# VDD VNW pfet_06v0 ad=0.2457p pd=1.465u as=0.2619p ps=1.685u w=0.945u l=0.5u
.ends

.subckt gf180mcu_fd_sc_mcu7t5v0__fillcap_16 VDD VNW VPW VSS
X0 VDD a_572_375# a_484_472# VNW pfet_06v0 ad=0.5368p pd=3.32u as=0.5368p ps=3.32u w=1.22u l=1u
X1 a_572_375# a_484_472# VSS VPW nfet_06v0 ad=0.3608p pd=2.52u as=0.3608p ps=2.52u w=0.82u l=1u
X2 a_124_375# a_36_472# VSS VPW nfet_06v0 ad=0.3608p pd=2.52u as=0.3608p ps=2.52u w=0.82u l=1u
X3 a_1468_375# a_1380_472# VSS VPW nfet_06v0 ad=0.3608p pd=2.52u as=0.3608p ps=2.52u w=0.82u l=1u
X4 VDD a_1020_375# a_932_472# VNW pfet_06v0 ad=0.5368p pd=3.32u as=0.5368p ps=3.32u w=1.22u l=1u
X5 VDD a_1468_375# a_1380_472# VNW pfet_06v0 ad=0.5368p pd=3.32u as=0.5368p ps=3.32u w=1.22u l=1u
X6 VDD a_124_375# a_36_472# VNW pfet_06v0 ad=0.5368p pd=3.32u as=0.5368p ps=3.32u w=1.22u l=1u
X7 a_1020_375# a_932_472# VSS VPW nfet_06v0 ad=0.3608p pd=2.52u as=0.3608p ps=2.52u w=0.82u l=1u
.ends

.subckt gf180mcu_fd_sc_mcu7t5v0__buf_2 I Z VDD VNW VPW VSS
X0 Z a_36_68# VDD VNW pfet_06v0 ad=0.3782p pd=1.84u as=0.4941p ps=2.03u w=1.22u l=0.5u
X1 VSS I a_36_68# VPW nfet_06v0 ad=0.2911p pd=1.53u as=0.3608p ps=2.52u w=0.82u l=0.6u
X2 Z a_36_68# VSS VPW nfet_06v0 ad=0.2132p pd=1.34u as=0.2911p ps=1.53u w=0.82u l=0.6u
X3 VDD I a_36_68# VNW pfet_06v0 ad=0.4941p pd=2.03u as=0.5368p ps=3.32u w=1.22u l=0.5u
X4 VSS a_36_68# Z VPW nfet_06v0 ad=0.3608p pd=2.52u as=0.2132p ps=1.34u w=0.82u l=0.6u
X5 VDD a_36_68# Z VNW pfet_06v0 ad=0.5368p pd=3.32u as=0.3782p ps=1.84u w=1.22u l=0.5u
.ends

.subckt gf180mcu_fd_sc_mcu7t5v0__fillcap_32 VDD VNW VPW VSS
X0 VDD a_572_375# a_484_472# VNW pfet_06v0 ad=0.5368p pd=3.32u as=0.5368p ps=3.32u w=1.22u l=1u
X1 VDD a_2364_375# a_2276_472# VNW pfet_06v0 ad=0.5368p pd=3.32u as=0.5368p ps=3.32u w=1.22u l=1u
X2 a_572_375# a_484_472# VSS VPW nfet_06v0 ad=0.3608p pd=2.52u as=0.3608p ps=2.52u w=0.82u l=1u
X3 VDD a_1916_375# a_1828_472# VNW pfet_06v0 ad=0.5368p pd=3.32u as=0.5368p ps=3.32u w=1.22u l=1u
X4 a_124_375# a_36_472# VSS VPW nfet_06v0 ad=0.3608p pd=2.52u as=0.3608p ps=2.52u w=0.82u l=1u
X5 a_1916_375# a_1828_472# VSS VPW nfet_06v0 ad=0.3608p pd=2.52u as=0.3608p ps=2.52u w=0.82u l=1u
X6 a_1468_375# a_1380_472# VSS VPW nfet_06v0 ad=0.3608p pd=2.52u as=0.3608p ps=2.52u w=0.82u l=1u
X7 a_2812_375# a_2724_472# VSS VPW nfet_06v0 ad=0.3608p pd=2.52u as=0.3608p ps=2.52u w=0.82u l=1u
X8 VDD a_3260_375# a_3172_472# VNW pfet_06v0 ad=0.5368p pd=3.32u as=0.5368p ps=3.32u w=1.22u l=1u
X9 a_2364_375# a_2276_472# VSS VPW nfet_06v0 ad=0.3608p pd=2.52u as=0.3608p ps=2.52u w=0.82u l=1u
X10 VDD a_2812_375# a_2724_472# VNW pfet_06v0 ad=0.5368p pd=3.32u as=0.5368p ps=3.32u w=1.22u l=1u
X11 a_3260_375# a_3172_472# VSS VPW nfet_06v0 ad=0.3608p pd=2.52u as=0.3608p ps=2.52u w=0.82u l=1u
X12 VDD a_1020_375# a_932_472# VNW pfet_06v0 ad=0.5368p pd=3.32u as=0.5368p ps=3.32u w=1.22u l=1u
X13 VDD a_1468_375# a_1380_472# VNW pfet_06v0 ad=0.5368p pd=3.32u as=0.5368p ps=3.32u w=1.22u l=1u
X14 VDD a_124_375# a_36_472# VNW pfet_06v0 ad=0.5368p pd=3.32u as=0.5368p ps=3.32u w=1.22u l=1u
X15 a_1020_375# a_932_472# VSS VPW nfet_06v0 ad=0.3608p pd=2.52u as=0.3608p ps=2.52u w=0.82u l=1u
.ends

.subckt gf180mcu_fd_sc_mcu7t5v0__mux2_2 I0 I1 S Z VDD VNW VPW VSS
X0 a_1152_472# S a_124_24# VNW pfet_06v0 ad=0.1464p pd=1.46u as=0.3172p ps=1.74u w=1.22u l=0.5u
X1 a_692_68# I1 VSS VPW nfet_06v0 ad=98.39999f pd=1.06u as=0.2132p ps=1.34u w=0.82u l=0.6u
X2 a_124_24# S a_692_68# VPW nfet_06v0 ad=0.2132p pd=1.34u as=98.39999f ps=1.06u w=0.82u l=0.6u
X3 Z a_124_24# VSS VPW nfet_06v0 ad=0.2132p pd=1.34u as=0.3608p ps=2.52u w=0.82u l=0.6u
X4 a_848_380# S VSS VPW nfet_06v0 ad=0.3608p pd=2.52u as=0.2132p ps=1.34u w=0.82u l=0.6u
X5 VDD a_124_24# Z VNW pfet_06v0 ad=0.4392p pd=1.94u as=0.3477p ps=1.79u w=1.22u l=0.5u
X6 VDD I0 a_1152_472# VNW pfet_06v0 ad=0.3172p pd=1.74u as=0.1464p ps=1.46u w=1.22u l=0.5u
X7 a_692_472# I1 VDD VNW pfet_06v0 ad=0.4758p pd=2u as=0.4392p ps=1.94u w=1.22u l=0.5u
X8 a_848_380# S VDD VNW pfet_06v0 ad=0.5368p pd=3.32u as=0.3172p ps=1.74u w=1.22u l=0.5u
X9 Z a_124_24# VDD VNW pfet_06v0 ad=0.3477p pd=1.79u as=0.5368p ps=3.32u w=1.22u l=0.5u
X10 VSS I0 a_1084_68# VPW nfet_06v0 ad=0.2132p pd=1.34u as=0.1968p ps=1.3u w=0.82u l=0.6u
X11 a_1084_68# a_848_380# a_124_24# VPW nfet_06v0 ad=0.1968p pd=1.3u as=0.2132p ps=1.34u w=0.82u l=0.6u
X12 VSS a_124_24# Z VPW nfet_06v0 ad=0.2132p pd=1.34u as=0.2132p ps=1.34u w=0.82u l=0.6u
X13 a_124_24# a_848_380# a_692_472# VNW pfet_06v0 ad=0.3172p pd=1.74u as=0.4758p ps=2u w=1.22u l=0.5u
.ends

.subckt gf180mcu_fd_sc_mcu7t5v0__mux4_1 I0 I1 I2 I3 S0 S1 Z VDD VNW VPW VSS
X0 VDD S1 a_1525_369# VNW pfet_06v0 ad=0.17515p pd=1.185u as=0.2486p ps=2.01u w=0.565u l=0.5u
X1 a_2929_515# S0 a_1901_156# VNW pfet_06v0 ad=0.2034p pd=1.285u as=0.1469p ps=1.085u w=0.565u l=0.5u
X2 Z a_1081_112# VSS VPW nfet_06v0 ad=0.1672p pd=1.64u as=0.13075p ps=1.08u w=0.38u l=0.6u
X3 VSS I3 a_712_156# VPW nfet_06v0 ad=0.13075p pd=1.08u as=99.45f ps=0.91u w=0.365u l=0.6u
X4 Z a_1081_112# VDD VNW pfet_06v0 ad=0.3432p pd=2.44u as=0.24075p ps=1.48u w=0.78u l=0.5u
X5 VSS I0 a_2929_515# VPW nfet_06v0 ad=94.89999f pd=0.885u as=94.89999f ps=0.885u w=0.365u l=0.6u
X6 VDD I3 a_712_156# VNW pfet_06v0 ad=0.24075p pd=1.48u as=0.1596p ps=1.13u w=0.565u l=0.5u
X7 a_1901_156# S0 a_2521_156# VPW nfet_06v0 ad=94.89999f pd=0.885u as=94.89999f ps=0.885u w=0.365u l=0.6u
X8 a_468_156# a_348_112# a_224_515# VPW nfet_06v0 ad=0.11315p pd=0.985u as=94.89999f ps=0.885u w=0.365u l=0.6u
X9 a_468_156# S0 a_224_515# VNW pfet_06v0 ad=0.18645p pd=1.225u as=0.24295p ps=1.425u w=0.565u l=0.5u
X10 a_224_515# I2 VDD VNW pfet_06v0 ad=0.24295p pd=1.425u as=0.2486p ps=2.01u w=0.565u l=0.5u
X11 a_1901_156# S1 a_1081_112# VNW pfet_06v0 ad=0.2486p pd=2.01u as=0.2486p ps=1.445u w=0.565u l=0.5u
X12 a_712_156# S0 a_468_156# VPW nfet_06v0 ad=99.45f pd=0.91u as=0.11315p ps=0.985u w=0.365u l=0.6u
X13 a_348_112# S0 VDD VNW pfet_06v0 ad=0.2486p pd=2.01u as=0.17515p ps=1.185u w=0.565u l=0.5u
X14 a_1081_112# a_1525_369# a_468_156# VNW pfet_06v0 ad=0.2486p pd=1.445u as=0.36725p ps=2.43u w=0.565u l=0.5u
X15 a_712_156# a_348_112# a_468_156# VNW pfet_06v0 ad=0.1596p pd=1.13u as=0.18645p ps=1.225u w=0.565u l=0.5u
X16 a_2521_156# I1 VSS VPW nfet_06v0 ad=94.89999f pd=0.885u as=94.89999f ps=0.885u w=0.365u l=0.6u
X17 a_224_515# I2 VSS VPW nfet_06v0 ad=94.89999f pd=0.885u as=0.1606p ps=1.61u w=0.365u l=0.6u
X18 a_348_112# S0 VSS VPW nfet_06v0 ad=0.1606p pd=1.61u as=94.89999f ps=0.885u w=0.365u l=0.6u
X19 a_2521_156# I1 VDD VNW pfet_06v0 ad=0.1469p pd=1.085u as=0.17515p ps=1.185u w=0.565u l=0.5u
X20 VSS S1 a_1525_369# VPW nfet_06v0 ad=94.89999f pd=0.885u as=0.1606p ps=1.61u w=0.365u l=0.6u
X21 VDD I0 a_2929_515# VNW pfet_06v0 ad=0.17515p pd=1.185u as=0.2034p ps=1.285u w=0.565u l=0.5u
X22 a_2929_515# a_348_112# a_1901_156# VPW nfet_06v0 ad=94.89999f pd=0.885u as=94.89999f ps=0.885u w=0.365u l=0.6u
X23 a_1081_112# S1 a_468_156# VPW nfet_06v0 ad=0.11315p pd=0.985u as=0.26462p ps=2.18u w=0.365u l=0.6u
X24 a_1901_156# a_348_112# a_2521_156# VNW pfet_06v0 ad=0.1469p pd=1.085u as=0.1469p ps=1.085u w=0.565u l=0.5u
X25 a_1901_156# a_1525_369# a_1081_112# VPW nfet_06v0 ad=0.1606p pd=1.61u as=0.11315p ps=0.985u w=0.365u l=0.6u
.ends

.subckt gf180mcu_fd_sc_mcu7t5v0__buf_4 I Z VDD VNW VPW VSS
X0 Z a_224_472# VDD VNW pfet_06v0 ad=0.3782p pd=1.84u as=0.3782p ps=1.84u w=1.22u l=0.5u
X1 Z a_224_472# VSS VPW nfet_06v0 ad=0.2132p pd=1.34u as=0.2132p ps=1.34u w=0.82u l=0.6u
X2 VDD a_224_472# Z VNW pfet_06v0 ad=0.5368p pd=3.32u as=0.3782p ps=1.84u w=1.22u l=0.5u
X3 a_224_472# I VSS VPW nfet_06v0 ad=0.2132p pd=1.34u as=0.3608p ps=2.52u w=0.82u l=0.6u
X4 VDD I a_224_472# VNW pfet_06v0 ad=0.3782p pd=1.84u as=0.3782p ps=1.84u w=1.22u l=0.5u
X5 Z a_224_472# VDD VNW pfet_06v0 ad=0.3782p pd=1.84u as=0.3782p ps=1.84u w=1.22u l=0.5u
X6 VDD a_224_472# Z VNW pfet_06v0 ad=0.3782p pd=1.84u as=0.3782p ps=1.84u w=1.22u l=0.5u
X7 VSS a_224_472# Z VPW nfet_06v0 ad=0.3608p pd=2.52u as=0.2132p ps=1.34u w=0.82u l=0.6u
X8 VSS a_224_472# Z VPW nfet_06v0 ad=0.2132p pd=1.34u as=0.2132p ps=1.34u w=0.82u l=0.6u
X9 a_224_472# I VDD VNW pfet_06v0 ad=0.3782p pd=1.84u as=0.5368p ps=3.32u w=1.22u l=0.5u
X10 VSS I a_224_472# VPW nfet_06v0 ad=0.2132p pd=1.34u as=0.2132p ps=1.34u w=0.82u l=0.6u
X11 Z a_224_472# VSS VPW nfet_06v0 ad=0.2132p pd=1.34u as=0.2132p ps=1.34u w=0.82u l=0.6u
.ends

.subckt clb CLK1 CLK1_BUFF CLK2_BUFF CLK_CLB D IN[0] IN[1] OUT Q VDD VSS CLK2
XFILLER_3_2 VDD VDD VSS VSS gf180mcu_fd_sc_mcu7t5v0__fillcap_4
XFILLER_9_27 VDD VDD VSS VSS gf180mcu_fd_sc_mcu7t5v0__fillcap_4
X_09_ regbank_inst.net3 net2 REG\[2\] VDD VDD VSS VSS gf180mcu_fd_sc_mcu7t5v0__dffq_1
XFILLER_1_63 VDD VDD VSS VSS gf180mcu_fd_sc_mcu7t5v0__fillcap_4
X_08_ regbank_inst.net4 net2 REG\[1\] VDD VDD VSS VSS gf180mcu_fd_sc_mcu7t5v0__dffq_1
XFILLER_9_19 VDD VDD VSS VSS gf180mcu_fd_sc_mcu7t5v0__fillcap_8
X_07_ regbank_inst.net5 net2 net6 VDD VDD VSS VSS gf180mcu_fd_sc_mcu7t5v0__dffq_4
X_06_ net3 net1 regbank_inst.net1 VDD VDD VSS VSS gf180mcu_fd_sc_mcu7t5v0__dffq_1
X_05_ REG\[4\] net1 regbank_inst.net2 VDD VDD VSS VSS gf180mcu_fd_sc_mcu7t5v0__dffq_1
XFILLER_8_2 VDD VDD VSS VSS gf180mcu_fd_sc_mcu7t5v0__fillcap_16
X_04_ REG\[3\] net1 regbank_inst.net3 VDD VDD VSS VSS gf180mcu_fd_sc_mcu7t5v0__dffq_1
Xinput1 CLK1 net1 VDD VDD VSS VSS gf180mcu_fd_sc_mcu7t5v0__buf_2
X_03_ REG\[2\] net1 regbank_inst.net4 VDD VDD VSS VSS gf180mcu_fd_sc_mcu7t5v0__dffq_1
Xinput2 CLK2 net2 VDD VDD VSS VSS gf180mcu_fd_sc_mcu7t5v0__buf_2
X_02_ REG\[1\] net1 regbank_inst.net5 VDD VDD VSS VSS gf180mcu_fd_sc_mcu7t5v0__dffq_1
Xinput3 D net3 VDD VDD VSS VSS gf180mcu_fd_sc_mcu7t5v0__buf_2
XFILLER_6_2 VDD VDD VSS VSS gf180mcu_fd_sc_mcu7t5v0__fillcap_32
X_01_ LUT_OUT dff_q net6 OUT VDD VDD VSS VSS gf180mcu_fd_sc_mcu7t5v0__mux2_2
XFILLER_4_37 VDD VDD VSS VSS gf180mcu_fd_sc_mcu7t5v0__fillcap_4
X_00_ REG\[4\] REG\[3\] REG\[2\] REG\[1\] IN[1] IN[0] LUT_OUT VDD VDD VSS VSS gf180mcu_fd_sc_mcu7t5v0__mux4_1
XFILLER_4_2 VDD VDD VSS VSS gf180mcu_fd_sc_mcu7t5v0__fillcap_4
XFILLER_8_60 VDD VDD VSS VSS gf180mcu_fd_sc_mcu7t5v0__fillcap_8
XFILLER_8_45 VDD VDD VSS VSS gf180mcu_fd_sc_mcu7t5v0__fillcap_4
XFILLER_5_13 VDD VDD VSS VSS gf180mcu_fd_sc_mcu7t5v0__fillcap_8
XFILLER_2_37 VDD VDD VSS VSS gf180mcu_fd_sc_mcu7t5v0__fillcap_4
XFILLER_8_37 VDD VDD VSS VSS gf180mcu_fd_sc_mcu7t5v0__fillcap_8
X_14_ net2 net5 VDD VDD VSS VSS gf180mcu_fd_sc_mcu7t5v0__buf_2
X_13_ net1 net4 VDD VDD VSS VSS gf180mcu_fd_sc_mcu7t5v0__buf_2
X_12_ LUT_OUT CLK_CLB dff_q VDD VDD VSS VSS gf180mcu_fd_sc_mcu7t5v0__dffq_1
XFILLER_7_2 VDD VDD VSS VSS gf180mcu_fd_sc_mcu7t5v0__fillcap_32
X_11_ regbank_inst.net1 net2 REG\[4\] VDD VDD VSS VSS gf180mcu_fd_sc_mcu7t5v0__dffq_1
XFILLER_8_18 VDD VDD VSS VSS gf180mcu_fd_sc_mcu7t5v0__fillcap_8
X_10_ regbank_inst.net2 net2 REG\[3\] VDD VDD VSS VSS gf180mcu_fd_sc_mcu7t5v0__dffq_1
XFILLER_0_53 VDD VDD VSS VSS gf180mcu_fd_sc_mcu7t5v0__fillcap_4
Xoutput4 net4 CLK1_BUFF VDD VDD VSS VSS gf180mcu_fd_sc_mcu7t5v0__buf_4
Xoutput5 net5 CLK2_BUFF VDD VDD VSS VSS gf180mcu_fd_sc_mcu7t5v0__buf_4
XFILLER_0_45 VDD VDD VSS VSS gf180mcu_fd_sc_mcu7t5v0__fillcap_8
XFILLER_6_66 VDD VDD VSS VSS gf180mcu_fd_sc_mcu7t5v0__fillcap_4
Xoutput6 net6 Q VDD VDD VSS VSS gf180mcu_fd_sc_mcu7t5v0__buf_4
.ends

.subckt nfet_06v0_ZZEGQS a_n424_n350# a_n280_n174# a_n52_n174# a_n192_n218# a_192_n174#
+ a_52_n218#
X0 a_192_n174# a_52_n218# a_n52_n174# a_n424_n350# nfet_06v0 ad=0.66p pd=3.88u as=0.39p ps=2.02u w=1.5u l=0.7u
X1 a_n52_n174# a_n192_n218# a_n280_n174# a_n424_n350# nfet_06v0 ad=0.39p pd=2.02u as=0.66p ps=3.88u w=1.5u l=0.7u
.ends

.subckt nfet-com G1 D1 G2 D2 G3 D3 G4 D4 VSS
XXM23 D3 VSS G3 D3 G3 G3 D3 VSS VSS G3 nfet_06v0_52FGQA
Xnfet_06v0_52FGQA_0 D4 VSS G4 D4 G4 G4 D4 VSS VSS G4 nfet_06v0_52FGQA
Xnfet_06v0_ZZEGQS_0 VSS D2 VSS G2 D2 G2 nfet_06v0_ZZEGQS
XXM21 VSS D1 VSS G1 D1 G1 nfet_06v0_ZZEGQS
.ends

.subckt nfet_06v0_42FNXL a_436_n400# a_192_n400# a_n436_n444# a_n768_n400# a_n192_n444#
+ a_540_n444# a_n296_n400# a_n52_n400# a_680_n400# a_n680_n444# a_n540_n400# a_296_n444#
+ a_52_n444# VSUBS
X0 a_436_n400# a_296_n444# a_192_n400# VSUBS nfet_06v0 ad=1.04p pd=4.52u as=1.04p ps=4.52u w=4u l=0.7u
X1 a_680_n400# a_540_n444# a_436_n400# VSUBS nfet_06v0 ad=1.76p pd=8.88u as=1.04p ps=4.52u w=4u l=0.7u
X2 a_192_n400# a_52_n444# a_n52_n400# VSUBS nfet_06v0 ad=1.04p pd=4.52u as=1.04p ps=4.52u w=4u l=0.7u
X3 a_n52_n400# a_n192_n444# a_n296_n400# VSUBS nfet_06v0 ad=1.04p pd=4.52u as=1.04p ps=4.52u w=4u l=0.7u
X4 a_n296_n400# a_n436_n444# a_n540_n400# VSUBS nfet_06v0 ad=1.04p pd=4.52u as=1.04p ps=4.52u w=4u l=0.7u
X5 a_n540_n400# a_n680_n444# a_n768_n400# VSUBS nfet_06v0 ad=1.04p pd=4.52u as=1.76p ps=8.88u w=4u l=0.7u
.ends

.subckt pfet_06v0_LJSS4L a_376_n400# a_1764_n444# a_n590_n444# a_1122_n444# a_n376_n444#
+ a_908_n444# w_n2048_n530# a_n694_n400# a_480_n444# a_266_n444# a_n1660_n444# a_n1446_n444#
+ a_1660_n400# a_n52_n400# a_n1764_n400# a_1446_n400# a_804_n400# a_n1122_n400# a_1550_n444#
+ a_162_n400# a_1336_n444# a_n804_n444# a_694_n444# a_n162_n444# a_n480_n400# a_n908_n400#
+ a_n1874_n444# a_n266_n400# a_1874_n400# a_n1962_n400# a_52_n444# a_n1232_n444# a_1232_n400#
+ a_n1550_n400# a_n1018_n444# a_n1336_n400# a_1018_n400# a_590_n400#
X0 a_376_n400# a_266_n444# a_162_n400# w_n2048_n530# pfet_06v0 ad=1.04p pd=4.52u as=1.04p ps=4.52u w=4u l=0.55u
X1 a_1232_n400# a_1122_n444# a_1018_n400# w_n2048_n530# pfet_06v0 ad=1.04p pd=4.52u as=1.04p ps=4.52u w=4u l=0.55u
X2 a_n694_n400# a_n804_n444# a_n908_n400# w_n2048_n530# pfet_06v0 ad=1.04p pd=4.52u as=1.04p ps=4.52u w=4u l=0.55u
X3 a_n1550_n400# a_n1660_n444# a_n1764_n400# w_n2048_n530# pfet_06v0 ad=1.04p pd=4.52u as=1.04p ps=4.52u w=4u l=0.55u
X4 a_1446_n400# a_1336_n444# a_1232_n400# w_n2048_n530# pfet_06v0 ad=1.04p pd=4.52u as=1.04p ps=4.52u w=4u l=0.55u
X5 a_n908_n400# a_n1018_n444# a_n1122_n400# w_n2048_n530# pfet_06v0 ad=1.04p pd=4.52u as=1.04p ps=4.52u w=4u l=0.55u
X6 a_n52_n400# a_n162_n444# a_n266_n400# w_n2048_n530# pfet_06v0 ad=1.04p pd=4.52u as=1.04p ps=4.52u w=4u l=0.55u
X7 a_162_n400# a_52_n444# a_n52_n400# w_n2048_n530# pfet_06v0 ad=1.04p pd=4.52u as=1.04p ps=4.52u w=4u l=0.55u
X8 a_590_n400# a_480_n444# a_376_n400# w_n2048_n530# pfet_06v0 ad=1.04p pd=4.52u as=1.04p ps=4.52u w=4u l=0.55u
X9 a_n1764_n400# a_n1874_n444# a_n1962_n400# w_n2048_n530# pfet_06v0 ad=1.04p pd=4.52u as=1.76p ps=8.88u w=4u l=0.55u
X10 a_1018_n400# a_908_n444# a_804_n400# w_n2048_n530# pfet_06v0 ad=1.04p pd=4.52u as=1.04p ps=4.52u w=4u l=0.55u
X11 a_n266_n400# a_n376_n444# a_n480_n400# w_n2048_n530# pfet_06v0 ad=1.04p pd=4.52u as=1.04p ps=4.52u w=4u l=0.55u
X12 a_804_n400# a_694_n444# a_590_n400# w_n2048_n530# pfet_06v0 ad=1.04p pd=4.52u as=1.04p ps=4.52u w=4u l=0.55u
X13 a_1660_n400# a_1550_n444# a_1446_n400# w_n2048_n530# pfet_06v0 ad=1.04p pd=4.52u as=1.04p ps=4.52u w=4u l=0.55u
X14 a_n1122_n400# a_n1232_n444# a_n1336_n400# w_n2048_n530# pfet_06v0 ad=1.04p pd=4.52u as=1.04p ps=4.52u w=4u l=0.55u
X15 a_n480_n400# a_n590_n444# a_n694_n400# w_n2048_n530# pfet_06v0 ad=1.04p pd=4.52u as=1.04p ps=4.52u w=4u l=0.55u
X16 a_1874_n400# a_1764_n444# a_1660_n400# w_n2048_n530# pfet_06v0 ad=1.76p pd=8.88u as=1.04p ps=4.52u w=4u l=0.55u
X17 a_n1336_n400# a_n1446_n444# a_n1550_n400# w_n2048_n530# pfet_06v0 ad=1.04p pd=4.52u as=1.04p ps=4.52u w=4u l=0.55u
.ends

.subckt trans-gate SWP IN OUT VDD VSS SWN
Xnfet_06v0_42FNXL_0 IN OUT SWN OUT SWN SWN OUT IN OUT SWN IN SWN SWN VSS nfet_06v0_42FNXL
Xpfet_06v0_LJSS4L_0 OUT SWP SWP SWP SWP SWP VDD IN SWP SWP SWP SWP OUT OUT OUT IN
+ OUT IN SWP IN SWP SWP SWP SWP OUT OUT SWP IN IN IN SWP SWP OUT IN SWP OUT IN IN
+ pfet_06v0_LJSS4L
.ends

.subckt gf180mcu_fd_sc_mcu9t5v0__latq_1 D E Q VDD VNW VPW VSS
X0 VSS a_1020_652# Q VPW nfet_06v0 ad=0.5808p pd=3.52u as=0.5808p ps=3.52u w=1.32u l=0.6u
X1 a_504_110# a_36_92# VDD VNW pfet_06v0 ad=0.44p pd=2.88u as=0.476p ps=2.18u w=1u l=0.5u
X2 VDD a_1020_652# Q VNW pfet_06v0 ad=0.8052p pd=4.54u as=0.8052p ps=4.54u w=1.83u l=0.5u
X3 a_1264_107# a_36_92# a_1020_652# VPW nfet_06v0 ad=0.263p pd=1.49u as=0.182p ps=1.22u w=0.7u l=0.6u
X4 VSS E a_36_92# VPW nfet_06v0 ad=0.263p pd=1.49u as=0.3476p ps=2.46u w=0.79u l=0.6u
X5 VSS a_1364_532# a_1264_107# VPW nfet_06v0 ad=0.2054p pd=1.31u as=0.263p ps=1.49u w=0.79u l=0.6u
X6 VDD E a_36_92# VNW pfet_06v0 ad=0.476p pd=2.18u as=0.6072p ps=3.64u w=1.38u l=0.5u
X7 VDD a_1364_532# a_1224_652# VNW pfet_06v0 ad=0.3588p pd=1.9u as=0.426p ps=2.08u w=1.38u l=0.5u
X8 a_872_652# D VDD VNW pfet_06v0 ad=0.12p pd=1.24u as=0.44p ps=2.88u w=1u l=0.5u
X9 a_1364_532# a_1020_652# VDD VNW pfet_06v0 ad=0.6072p pd=3.64u as=0.3588p ps=1.9u w=1.38u l=0.5u
X10 a_1020_652# a_504_110# a_872_107# VPW nfet_06v0 ad=0.182p pd=1.22u as=83.99999f ps=0.94u w=0.7u l=0.6u
X11 a_872_107# D VSS VPW nfet_06v0 ad=83.99999f pd=0.94u as=0.308p ps=2.28u w=0.7u l=0.6u
X12 a_1020_652# a_36_92# a_872_652# VNW pfet_06v0 ad=0.26p pd=1.52u as=0.12p ps=1.24u w=1u l=0.5u
X13 a_504_110# a_36_92# VSS VPW nfet_06v0 ad=0.308p pd=2.28u as=0.263p ps=1.49u w=0.7u l=0.6u
X14 a_1364_532# a_1020_652# VSS VPW nfet_06v0 ad=0.3476p pd=2.46u as=0.2054p ps=1.31u w=0.79u l=0.6u
X15 a_1224_652# a_504_110# a_1020_652# VNW pfet_06v0 ad=0.426p pd=2.08u as=0.26p ps=1.52u w=1u l=0.5u
.ends

.subckt gf180mcu_fd_sc_mcu9t5v0__and2_1 A1 A2 Z VDD VNW VPW VSS
X0 VDD A2 a_36_201# VNW pfet_06v0 ad=0.5054p pd=2.57u as=0.2132p ps=1.34u w=0.82u l=0.5u
X1 a_244_201# A1 a_36_201# VPW nfet_06v0 ad=0.1056p pd=0.98u as=0.2904p ps=2.2u w=0.66u l=0.6u
X2 Z a_36_201# VSS VPW nfet_06v0 ad=0.5808p pd=3.52u as=0.3894p ps=2.06u w=1.32u l=0.6u
X3 Z a_36_201# VDD VNW pfet_06v0 ad=0.8052p pd=4.54u as=0.5054p ps=2.57u w=1.83u l=0.5u
X4 VSS A2 a_244_201# VPW nfet_06v0 ad=0.3894p pd=2.06u as=0.1056p ps=0.98u w=0.66u l=0.6u
X5 a_36_201# A1 VDD VNW pfet_06v0 ad=0.2132p pd=1.34u as=0.3608p ps=2.52u w=0.82u l=0.5u
.ends

.subckt switch-cell VDD CLK1 Q D OUT CLK2 IN RSTN VSS
Xtrans-gate_0 trans-gate_0/SWP IN OUT VDD VSS trans-gate_0/SWN trans-gate
Xgf180mcu_fd_sc_mcu9t5v0__latq_1_0 D CLK1 gf180mcu_fd_sc_mcu9t5v0__latq_1_1/D VDD
+ VDD VSS VSS gf180mcu_fd_sc_mcu9t5v0__latq_1
Xgf180mcu_fd_sc_mcu9t5v0__latq_1_1 gf180mcu_fd_sc_mcu9t5v0__latq_1_1/D CLK2 Q VDD
+ VDD VSS VSS gf180mcu_fd_sc_mcu9t5v0__latq_1
Xgf180mcu_fd_sc_mcu9t5v0__inv_1_0 trans-gate_0/SWN trans-gate_0/SWP VDD VDD VSS VSS
+ gf180mcu_fd_sc_mcu9t5v0__inv_1
Xgf180mcu_fd_sc_mcu9t5v0__and2_1_0 Q RSTN trans-gate_0/SWN VDD VDD VSS VSS gf180mcu_fd_sc_mcu9t5v0__and2_1
.ends

.subckt switch-matrix-16x1 OUT[4] OUT[9] OUT[10] OUT[13] RSTN CLK1 IN Q D OUT[6] OUT[7]
+ OUT[0] OUT[12] OUT[5] OUT[15] CLK2 OUT[8] VDD OUT[1] OUT[11] OUT[2] OUT[14] VSS
+ OUT[3]
Xswitch-cell_15 VDD CLK1 Q switch-cell_16/Q OUT[0] CLK2 IN RSTN VSS switch-cell
Xswitch-cell_0 VDD CLK1 switch-cell_1/D D OUT[15] CLK2 IN RSTN VSS switch-cell
Xswitch-cell_16 VDD CLK1 switch-cell_16/Q switch-cell_16/D OUT[1] CLK2 IN RSTN VSS
+ switch-cell
Xswitch-cell_1 VDD CLK1 switch-cell_2/D switch-cell_1/D OUT[14] CLK2 IN RSTN VSS switch-cell
Xswitch-cell_2 VDD CLK1 switch-cell_3/D switch-cell_2/D OUT[13] CLK2 IN RSTN VSS switch-cell
Xswitch-cell_3 VDD CLK1 switch-cell_4/D switch-cell_3/D OUT[12] CLK2 IN RSTN VSS switch-cell
Xswitch-cell_4 VDD CLK1 switch-cell_5/D switch-cell_4/D OUT[11] CLK2 IN RSTN VSS switch-cell
Xswitch-cell_5 VDD CLK1 switch-cell_8/D switch-cell_5/D OUT[10] CLK2 IN RSTN VSS switch-cell
Xswitch-cell_6 VDD CLK1 switch-cell_9/D switch-cell_7/Q OUT[7] CLK2 IN RSTN VSS switch-cell
Xswitch-cell_7 VDD CLK1 switch-cell_7/Q switch-cell_8/Q OUT[8] CLK2 IN RSTN VSS switch-cell
Xswitch-cell_8 VDD CLK1 switch-cell_8/Q switch-cell_8/D OUT[9] CLK2 IN RSTN VSS switch-cell
Xswitch-cell_9 VDD CLK1 switch-cell_9/Q switch-cell_9/D OUT[6] CLK2 IN RSTN VSS switch-cell
Xswitch-cell_10 VDD CLK1 switch-cell_13/D switch-cell_11/Q OUT[3] CLK2 IN RSTN VSS
+ switch-cell
Xswitch-cell_11 VDD CLK1 switch-cell_11/Q switch-cell_12/Q OUT[4] CLK2 IN RSTN VSS
+ switch-cell
Xswitch-cell_13 VDD CLK1 switch-cell_16/D switch-cell_13/D OUT[2] CLK2 IN RSTN VSS
+ switch-cell
Xswitch-cell_12 VDD CLK1 switch-cell_12/Q switch-cell_9/Q OUT[5] CLK2 IN RSTN VSS
+ switch-cell
.ends

.subckt switch-matrix-16x70 RSTN Q OUT[14] OUT[13] OUT[12] OUT[11] OUT[10] OUT[9]
+ OUT[8] OUT[7] OUT[6] OUT[5] OUT[4] OUT[3] OUT[2] OUT[1] IN[59] IN[58] IN[57] IN[56]
+ IN[55] IN[54] IN[53] IN[52] IN[51] IN[50] IN[49] IN[48] IN[47] IN[46] IN[45] IN[44]
+ IN[43] IN[42] IN[41] IN[40] IN[39] IN[38] IN[37] IN[36] IN[35] IN[34] IN[33] IN[32]
+ IN[31] IN[30] IN[29] IN[28] IN[27] IN[26] IN[25] IN[24] IN[23] IN[22] IN[21] IN[20]
+ IN[19] IN[18] IN[17] IN[16] IN[15] IN[14] IN[13] IN[12] IN[11] IN[10] IN[9] IN[8]
+ IN[7] IN[6] IN[5] IN[4] IN[3] IN[2] IN[1] IN[0] D CLK2 CLK1 OUT[15] OUT[0] VDD VSS
Xswitch-matrix-16x1_70 OUT[4] OUT[9] OUT[10] OUT[13] RSTN CLK1 IN[0] Q switch-matrix-16x1_71/Q
+ OUT[6] OUT[7] OUT[0] OUT[12] OUT[5] OUT[15] CLK2 OUT[8] VDD OUT[1] OUT[11] OUT[2]
+ OUT[14] VSS OUT[3] switch-matrix-16x1
Xswitch-matrix-16x1_50 OUT[4] OUT[9] OUT[10] OUT[13] RSTN CLK1 IN[56] switch-matrix-16x1_50/Q
+ switch-matrix-16x1_51/Q OUT[6] OUT[7] OUT[0] OUT[12] OUT[5] OUT[15] CLK2 OUT[8]
+ VDD OUT[1] OUT[11] OUT[2] OUT[14] VSS OUT[3] switch-matrix-16x1
Xswitch-matrix-16x1_72 OUT[4] OUT[9] OUT[10] OUT[13] RSTN CLK1 IN[2] switch-matrix-16x1_72/Q
+ switch-matrix-16x1_73/Q OUT[6] OUT[7] OUT[0] OUT[12] OUT[5] OUT[15] CLK2 OUT[8]
+ VDD OUT[1] OUT[11] OUT[2] OUT[14] VSS OUT[3] switch-matrix-16x1
Xswitch-matrix-16x1_71 OUT[4] OUT[9] OUT[10] OUT[13] RSTN CLK1 IN[1] switch-matrix-16x1_71/Q
+ switch-matrix-16x1_72/Q OUT[6] OUT[7] OUT[0] OUT[12] OUT[5] OUT[15] CLK2 OUT[8]
+ VDD OUT[1] OUT[11] OUT[2] OUT[14] VSS OUT[3] switch-matrix-16x1
Xswitch-matrix-16x1_51 OUT[4] OUT[9] OUT[10] OUT[13] RSTN CLK1 IN[57] switch-matrix-16x1_51/Q
+ switch-matrix-16x1_52/Q OUT[6] OUT[7] OUT[0] OUT[12] OUT[5] OUT[15] CLK2 OUT[8]
+ VDD OUT[1] OUT[11] OUT[2] OUT[14] VSS OUT[3] switch-matrix-16x1
Xswitch-matrix-16x1_40 OUT[4] OUT[9] OUT[10] OUT[13] RSTN CLK1 IN[55] switch-matrix-16x1_41/D
+ switch-matrix-16x1_50/Q OUT[6] OUT[7] OUT[0] OUT[12] OUT[5] OUT[15] CLK2 OUT[8]
+ VDD OUT[1] OUT[11] OUT[2] OUT[14] VSS OUT[3] switch-matrix-16x1
Xswitch-matrix-16x1_0 OUT[4] OUT[9] OUT[10] OUT[13] RSTN CLK1 IN[6] switch-matrix-16x1_0/Q
+ switch-matrix-16x1_1/Q OUT[6] OUT[7] OUT[0] OUT[12] OUT[5] OUT[15] CLK2 OUT[8] VDD
+ OUT[1] OUT[11] OUT[2] OUT[14] VSS OUT[3] switch-matrix-16x1
Xswitch-matrix-16x1_73 OUT[4] OUT[9] OUT[10] OUT[13] RSTN CLK1 IN[3] switch-matrix-16x1_73/Q
+ switch-matrix-16x1_74/Q OUT[6] OUT[7] OUT[0] OUT[12] OUT[5] OUT[15] CLK2 OUT[8]
+ VDD OUT[1] OUT[11] OUT[2] OUT[14] VSS OUT[3] switch-matrix-16x1
Xswitch-matrix-16x1_52 OUT[4] OUT[9] OUT[10] OUT[13] RSTN CLK1 IN[58] switch-matrix-16x1_52/Q
+ switch-matrix-16x1_53/Q OUT[6] OUT[7] OUT[0] OUT[12] OUT[5] OUT[15] CLK2 OUT[8]
+ VDD OUT[1] OUT[11] OUT[2] OUT[14] VSS OUT[3] switch-matrix-16x1
Xswitch-matrix-16x1_41 OUT[4] OUT[9] OUT[10] OUT[13] RSTN CLK1 IN[54] switch-matrix-16x1_42/D
+ switch-matrix-16x1_41/D OUT[6] OUT[7] OUT[0] OUT[12] OUT[5] OUT[15] CLK2 OUT[8]
+ VDD OUT[1] OUT[11] OUT[2] OUT[14] VSS OUT[3] switch-matrix-16x1
Xswitch-matrix-16x1_30 OUT[4] OUT[9] OUT[10] OUT[13] RSTN CLK1 IN[36] switch-matrix-16x1_30/Q
+ switch-matrix-16x1_31/Q OUT[6] OUT[7] OUT[0] OUT[12] OUT[5] OUT[15] CLK2 OUT[8]
+ VDD OUT[1] OUT[11] OUT[2] OUT[14] VSS OUT[3] switch-matrix-16x1
Xswitch-matrix-16x1_1 OUT[4] OUT[9] OUT[10] OUT[13] RSTN CLK1 IN[7] switch-matrix-16x1_1/Q
+ switch-matrix-16x1_2/Q OUT[6] OUT[7] OUT[0] OUT[12] OUT[5] OUT[15] CLK2 OUT[8] VDD
+ OUT[1] OUT[11] OUT[2] OUT[14] VSS OUT[3] switch-matrix-16x1
Xswitch-matrix-16x1_74 OUT[4] OUT[9] OUT[10] OUT[13] RSTN CLK1 IN[4] switch-matrix-16x1_74/Q
+ switch-matrix-16x1_75/Q OUT[6] OUT[7] OUT[0] OUT[12] OUT[5] OUT[15] CLK2 OUT[8]
+ VDD OUT[1] OUT[11] OUT[2] OUT[14] VSS OUT[3] switch-matrix-16x1
Xswitch-matrix-16x1_53 OUT[4] OUT[9] OUT[10] OUT[13] RSTN CLK1 IN[59] switch-matrix-16x1_53/Q
+ D OUT[6] OUT[7] OUT[0] OUT[12] OUT[5] OUT[15] CLK2 OUT[8] VDD OUT[1] OUT[11] OUT[2]
+ OUT[14] VSS OUT[3] switch-matrix-16x1
Xswitch-matrix-16x1_42 OUT[4] OUT[9] OUT[10] OUT[13] RSTN CLK1 IN[53] switch-matrix-16x1_43/D
+ switch-matrix-16x1_42/D OUT[6] OUT[7] OUT[0] OUT[12] OUT[5] OUT[15] CLK2 OUT[8]
+ VDD OUT[1] OUT[11] OUT[2] OUT[14] VSS OUT[3] switch-matrix-16x1
Xswitch-matrix-16x1_31 OUT[4] OUT[9] OUT[10] OUT[13] RSTN CLK1 IN[37] switch-matrix-16x1_31/Q
+ switch-matrix-16x1_32/Q OUT[6] OUT[7] OUT[0] OUT[12] OUT[5] OUT[15] CLK2 OUT[8]
+ VDD OUT[1] OUT[11] OUT[2] OUT[14] VSS OUT[3] switch-matrix-16x1
Xswitch-matrix-16x1_20 OUT[4] OUT[9] OUT[10] OUT[13] RSTN CLK1 IN[31] switch-matrix-16x1_25/D
+ switch-matrix-16x1_21/Q OUT[6] OUT[7] OUT[0] OUT[12] OUT[5] OUT[15] CLK2 OUT[8]
+ VDD OUT[1] OUT[11] OUT[2] OUT[14] VSS OUT[3] switch-matrix-16x1
Xswitch-matrix-16x1_2 OUT[4] OUT[9] OUT[10] OUT[13] RSTN CLK1 IN[8] switch-matrix-16x1_2/Q
+ switch-matrix-16x1_3/Q OUT[6] OUT[7] OUT[0] OUT[12] OUT[5] OUT[15] CLK2 OUT[8] VDD
+ OUT[1] OUT[11] OUT[2] OUT[14] VSS OUT[3] switch-matrix-16x1
Xswitch-matrix-16x1_75 OUT[4] OUT[9] OUT[10] OUT[13] RSTN CLK1 IN[5] switch-matrix-16x1_75/Q
+ switch-matrix-16x1_0/Q OUT[6] OUT[7] OUT[0] OUT[12] OUT[5] OUT[15] CLK2 OUT[8] VDD
+ OUT[1] OUT[11] OUT[2] OUT[14] VSS OUT[3] switch-matrix-16x1
Xswitch-matrix-16x1_43 OUT[4] OUT[9] OUT[10] OUT[13] RSTN CLK1 IN[52] switch-matrix-16x1_44/D
+ switch-matrix-16x1_43/D OUT[6] OUT[7] OUT[0] OUT[12] OUT[5] OUT[15] CLK2 OUT[8]
+ VDD OUT[1] OUT[11] OUT[2] OUT[14] VSS OUT[3] switch-matrix-16x1
Xswitch-matrix-16x1_32 OUT[4] OUT[9] OUT[10] OUT[13] RSTN CLK1 IN[38] switch-matrix-16x1_32/Q
+ switch-matrix-16x1_33/Q OUT[6] OUT[7] OUT[0] OUT[12] OUT[5] OUT[15] CLK2 OUT[8]
+ VDD OUT[1] OUT[11] OUT[2] OUT[14] VSS OUT[3] switch-matrix-16x1
Xswitch-matrix-16x1_21 OUT[4] OUT[9] OUT[10] OUT[13] RSTN CLK1 IN[32] switch-matrix-16x1_21/Q
+ switch-matrix-16x1_22/Q OUT[6] OUT[7] OUT[0] OUT[12] OUT[5] OUT[15] CLK2 OUT[8]
+ VDD OUT[1] OUT[11] OUT[2] OUT[14] VSS OUT[3] switch-matrix-16x1
Xswitch-matrix-16x1_10 OUT[4] OUT[9] OUT[10] OUT[13] RSTN CLK1 IN[17] switch-matrix-16x1_11/D
+ switch-matrix-16x1_12/Q OUT[6] OUT[7] OUT[0] OUT[12] OUT[5] OUT[15] CLK2 OUT[8]
+ VDD OUT[1] OUT[11] OUT[2] OUT[14] VSS OUT[3] switch-matrix-16x1
Xswitch-matrix-16x1_3 OUT[4] OUT[9] OUT[10] OUT[13] RSTN CLK1 IN[9] switch-matrix-16x1_3/Q
+ switch-matrix-16x1_4/Q OUT[6] OUT[7] OUT[0] OUT[12] OUT[5] OUT[15] CLK2 OUT[8] VDD
+ OUT[1] OUT[11] OUT[2] OUT[14] VSS OUT[3] switch-matrix-16x1
Xswitch-matrix-16x1_44 OUT[4] OUT[9] OUT[10] OUT[13] RSTN CLK1 IN[51] switch-matrix-16x1_45/D
+ switch-matrix-16x1_44/D OUT[6] OUT[7] OUT[0] OUT[12] OUT[5] OUT[15] CLK2 OUT[8]
+ VDD OUT[1] OUT[11] OUT[2] OUT[14] VSS OUT[3] switch-matrix-16x1
Xswitch-matrix-16x1_33 OUT[4] OUT[9] OUT[10] OUT[13] RSTN CLK1 IN[39] switch-matrix-16x1_33/Q
+ switch-matrix-16x1_34/Q OUT[6] OUT[7] OUT[0] OUT[12] OUT[5] OUT[15] CLK2 OUT[8]
+ VDD OUT[1] OUT[11] OUT[2] OUT[14] VSS OUT[3] switch-matrix-16x1
Xswitch-matrix-16x1_22 OUT[4] OUT[9] OUT[10] OUT[13] RSTN CLK1 IN[33] switch-matrix-16x1_22/Q
+ switch-matrix-16x1_23/Q OUT[6] OUT[7] OUT[0] OUT[12] OUT[5] OUT[15] CLK2 OUT[8]
+ VDD OUT[1] OUT[11] OUT[2] OUT[14] VSS OUT[3] switch-matrix-16x1
Xswitch-matrix-16x1_11 OUT[4] OUT[9] OUT[10] OUT[13] RSTN CLK1 IN[16] switch-matrix-16x1_5/D
+ switch-matrix-16x1_11/D OUT[6] OUT[7] OUT[0] OUT[12] OUT[5] OUT[15] CLK2 OUT[8]
+ VDD OUT[1] OUT[11] OUT[2] OUT[14] VSS OUT[3] switch-matrix-16x1
Xswitch-matrix-16x1_5 OUT[4] OUT[9] OUT[10] OUT[13] RSTN CLK1 IN[15] switch-matrix-16x1_6/D
+ switch-matrix-16x1_5/D OUT[6] OUT[7] OUT[0] OUT[12] OUT[5] OUT[15] CLK2 OUT[8] VDD
+ OUT[1] OUT[11] OUT[2] OUT[14] VSS OUT[3] switch-matrix-16x1
Xswitch-matrix-16x1_4 OUT[4] OUT[9] OUT[10] OUT[13] RSTN CLK1 IN[10] switch-matrix-16x1_4/Q
+ switch-matrix-16x1_9/Q OUT[6] OUT[7] OUT[0] OUT[12] OUT[5] OUT[15] CLK2 OUT[8] VDD
+ OUT[1] OUT[11] OUT[2] OUT[14] VSS OUT[3] switch-matrix-16x1
Xswitch-matrix-16x1_45 OUT[4] OUT[9] OUT[10] OUT[13] RSTN CLK1 IN[50] switch-matrix-16x1_46/D
+ switch-matrix-16x1_45/D OUT[6] OUT[7] OUT[0] OUT[12] OUT[5] OUT[15] CLK2 OUT[8]
+ VDD OUT[1] OUT[11] OUT[2] OUT[14] VSS OUT[3] switch-matrix-16x1
Xswitch-matrix-16x1_34 OUT[4] OUT[9] OUT[10] OUT[13] RSTN CLK1 IN[40] switch-matrix-16x1_34/Q
+ switch-matrix-16x1_39/Q OUT[6] OUT[7] OUT[0] OUT[12] OUT[5] OUT[15] CLK2 OUT[8]
+ VDD OUT[1] OUT[11] OUT[2] OUT[14] VSS OUT[3] switch-matrix-16x1
Xswitch-matrix-16x1_23 OUT[4] OUT[9] OUT[10] OUT[13] RSTN CLK1 IN[34] switch-matrix-16x1_23/Q
+ switch-matrix-16x1_24/Q OUT[6] OUT[7] OUT[0] OUT[12] OUT[5] OUT[15] CLK2 OUT[8]
+ VDD OUT[1] OUT[11] OUT[2] OUT[14] VSS OUT[3] switch-matrix-16x1
Xswitch-matrix-16x1_12 OUT[4] OUT[9] OUT[10] OUT[13] RSTN CLK1 IN[18] switch-matrix-16x1_12/Q
+ switch-matrix-16x1_13/Q OUT[6] OUT[7] OUT[0] OUT[12] OUT[5] OUT[15] CLK2 OUT[8]
+ VDD OUT[1] OUT[11] OUT[2] OUT[14] VSS OUT[3] switch-matrix-16x1
Xswitch-matrix-16x1_6 OUT[4] OUT[9] OUT[10] OUT[13] RSTN CLK1 IN[14] switch-matrix-16x1_7/D
+ switch-matrix-16x1_6/D OUT[6] OUT[7] OUT[0] OUT[12] OUT[5] OUT[15] CLK2 OUT[8] VDD
+ OUT[1] OUT[11] OUT[2] OUT[14] VSS OUT[3] switch-matrix-16x1
Xswitch-matrix-16x1_46 OUT[4] OUT[9] OUT[10] OUT[13] RSTN CLK1 IN[49] switch-matrix-16x1_47/D
+ switch-matrix-16x1_46/D OUT[6] OUT[7] OUT[0] OUT[12] OUT[5] OUT[15] CLK2 OUT[8]
+ VDD OUT[1] OUT[11] OUT[2] OUT[14] VSS OUT[3] switch-matrix-16x1
Xswitch-matrix-16x1_35 OUT[4] OUT[9] OUT[10] OUT[13] RSTN CLK1 IN[45] switch-matrix-16x1_36/D
+ switch-matrix-16x1_49/Q OUT[6] OUT[7] OUT[0] OUT[12] OUT[5] OUT[15] CLK2 OUT[8]
+ VDD OUT[1] OUT[11] OUT[2] OUT[14] VSS OUT[3] switch-matrix-16x1
Xswitch-matrix-16x1_24 OUT[4] OUT[9] OUT[10] OUT[13] RSTN CLK1 IN[35] switch-matrix-16x1_24/Q
+ switch-matrix-16x1_30/Q OUT[6] OUT[7] OUT[0] OUT[12] OUT[5] OUT[15] CLK2 OUT[8]
+ VDD OUT[1] OUT[11] OUT[2] OUT[14] VSS OUT[3] switch-matrix-16x1
Xswitch-matrix-16x1_13 OUT[4] OUT[9] OUT[10] OUT[13] RSTN CLK1 IN[19] switch-matrix-16x1_13/Q
+ switch-matrix-16x1_14/Q OUT[6] OUT[7] OUT[0] OUT[12] OUT[5] OUT[15] CLK2 OUT[8]
+ VDD OUT[1] OUT[11] OUT[2] OUT[14] VSS OUT[3] switch-matrix-16x1
Xswitch-matrix-16x1_7 OUT[4] OUT[9] OUT[10] OUT[13] RSTN CLK1 IN[13] switch-matrix-16x1_8/D
+ switch-matrix-16x1_7/D OUT[6] OUT[7] OUT[0] OUT[12] OUT[5] OUT[15] CLK2 OUT[8] VDD
+ OUT[1] OUT[11] OUT[2] OUT[14] VSS OUT[3] switch-matrix-16x1
Xswitch-matrix-16x1_47 OUT[4] OUT[9] OUT[10] OUT[13] RSTN CLK1 IN[48] switch-matrix-16x1_48/D
+ switch-matrix-16x1_47/D OUT[6] OUT[7] OUT[0] OUT[12] OUT[5] OUT[15] CLK2 OUT[8]
+ VDD OUT[1] OUT[11] OUT[2] OUT[14] VSS OUT[3] switch-matrix-16x1
Xswitch-matrix-16x1_48 OUT[4] OUT[9] OUT[10] OUT[13] RSTN CLK1 IN[47] switch-matrix-16x1_49/D
+ switch-matrix-16x1_48/D OUT[6] OUT[7] OUT[0] OUT[12] OUT[5] OUT[15] CLK2 OUT[8]
+ VDD OUT[1] OUT[11] OUT[2] OUT[14] VSS OUT[3] switch-matrix-16x1
Xswitch-matrix-16x1_36 OUT[4] OUT[9] OUT[10] OUT[13] RSTN CLK1 IN[44] switch-matrix-16x1_37/D
+ switch-matrix-16x1_36/D OUT[6] OUT[7] OUT[0] OUT[12] OUT[5] OUT[15] CLK2 OUT[8]
+ VDD OUT[1] OUT[11] OUT[2] OUT[14] VSS OUT[3] switch-matrix-16x1
Xswitch-matrix-16x1_37 OUT[4] OUT[9] OUT[10] OUT[13] RSTN CLK1 IN[43] switch-matrix-16x1_38/D
+ switch-matrix-16x1_37/D OUT[6] OUT[7] OUT[0] OUT[12] OUT[5] OUT[15] CLK2 OUT[8]
+ VDD OUT[1] OUT[11] OUT[2] OUT[14] VSS OUT[3] switch-matrix-16x1
Xswitch-matrix-16x1_25 OUT[4] OUT[9] OUT[10] OUT[13] RSTN CLK1 IN[30] switch-matrix-16x1_26/D
+ switch-matrix-16x1_25/D OUT[6] OUT[7] OUT[0] OUT[12] OUT[5] OUT[15] CLK2 OUT[8]
+ VDD OUT[1] OUT[11] OUT[2] OUT[14] VSS OUT[3] switch-matrix-16x1
Xswitch-matrix-16x1_26 OUT[4] OUT[9] OUT[10] OUT[13] RSTN CLK1 IN[29] switch-matrix-16x1_27/D
+ switch-matrix-16x1_26/D OUT[6] OUT[7] OUT[0] OUT[12] OUT[5] OUT[15] CLK2 OUT[8]
+ VDD OUT[1] OUT[11] OUT[2] OUT[14] VSS OUT[3] switch-matrix-16x1
Xswitch-matrix-16x1_15 OUT[4] OUT[9] OUT[10] OUT[13] RSTN CLK1 IN[21] switch-matrix-16x1_15/Q
+ switch-matrix-16x1_16/Q OUT[6] OUT[7] OUT[0] OUT[12] OUT[5] OUT[15] CLK2 OUT[8]
+ VDD OUT[1] OUT[11] OUT[2] OUT[14] VSS OUT[3] switch-matrix-16x1
Xswitch-matrix-16x1_14 OUT[4] OUT[9] OUT[10] OUT[13] RSTN CLK1 IN[20] switch-matrix-16x1_14/Q
+ switch-matrix-16x1_15/Q OUT[6] OUT[7] OUT[0] OUT[12] OUT[5] OUT[15] CLK2 OUT[8]
+ VDD OUT[1] OUT[11] OUT[2] OUT[14] VSS OUT[3] switch-matrix-16x1
Xswitch-matrix-16x1_8 OUT[4] OUT[9] OUT[10] OUT[13] RSTN CLK1 IN[12] switch-matrix-16x1_9/D
+ switch-matrix-16x1_8/D OUT[6] OUT[7] OUT[0] OUT[12] OUT[5] OUT[15] CLK2 OUT[8] VDD
+ OUT[1] OUT[11] OUT[2] OUT[14] VSS OUT[3] switch-matrix-16x1
Xswitch-matrix-16x1_49 OUT[4] OUT[9] OUT[10] OUT[13] RSTN CLK1 IN[46] switch-matrix-16x1_49/Q
+ switch-matrix-16x1_49/D OUT[6] OUT[7] OUT[0] OUT[12] OUT[5] OUT[15] CLK2 OUT[8]
+ VDD OUT[1] OUT[11] OUT[2] OUT[14] VSS OUT[3] switch-matrix-16x1
Xswitch-matrix-16x1_38 OUT[4] OUT[9] OUT[10] OUT[13] RSTN CLK1 IN[42] switch-matrix-16x1_39/D
+ switch-matrix-16x1_38/D OUT[6] OUT[7] OUT[0] OUT[12] OUT[5] OUT[15] CLK2 OUT[8]
+ VDD OUT[1] OUT[11] OUT[2] OUT[14] VSS OUT[3] switch-matrix-16x1
Xswitch-matrix-16x1_27 OUT[4] OUT[9] OUT[10] OUT[13] RSTN CLK1 IN[28] switch-matrix-16x1_28/D
+ switch-matrix-16x1_27/D OUT[6] OUT[7] OUT[0] OUT[12] OUT[5] OUT[15] CLK2 OUT[8]
+ VDD OUT[1] OUT[11] OUT[2] OUT[14] VSS OUT[3] switch-matrix-16x1
Xswitch-matrix-16x1_16 OUT[4] OUT[9] OUT[10] OUT[13] RSTN CLK1 IN[22] switch-matrix-16x1_16/Q
+ switch-matrix-16x1_17/Q OUT[6] OUT[7] OUT[0] OUT[12] OUT[5] OUT[15] CLK2 OUT[8]
+ VDD OUT[1] OUT[11] OUT[2] OUT[14] VSS OUT[3] switch-matrix-16x1
Xswitch-matrix-16x1_9 OUT[4] OUT[9] OUT[10] OUT[13] RSTN CLK1 IN[11] switch-matrix-16x1_9/Q
+ switch-matrix-16x1_9/D OUT[6] OUT[7] OUT[0] OUT[12] OUT[5] OUT[15] CLK2 OUT[8] VDD
+ OUT[1] OUT[11] OUT[2] OUT[14] VSS OUT[3] switch-matrix-16x1
Xswitch-matrix-16x1_39 OUT[4] OUT[9] OUT[10] OUT[13] RSTN CLK1 IN[41] switch-matrix-16x1_39/Q
+ switch-matrix-16x1_39/D OUT[6] OUT[7] OUT[0] OUT[12] OUT[5] OUT[15] CLK2 OUT[8]
+ VDD OUT[1] OUT[11] OUT[2] OUT[14] VSS OUT[3] switch-matrix-16x1
Xswitch-matrix-16x1_28 OUT[4] OUT[9] OUT[10] OUT[13] RSTN CLK1 IN[27] switch-matrix-16x1_29/D
+ switch-matrix-16x1_28/D OUT[6] OUT[7] OUT[0] OUT[12] OUT[5] OUT[15] CLK2 OUT[8]
+ VDD OUT[1] OUT[11] OUT[2] OUT[14] VSS OUT[3] switch-matrix-16x1
Xswitch-matrix-16x1_17 OUT[4] OUT[9] OUT[10] OUT[13] RSTN CLK1 IN[23] switch-matrix-16x1_17/Q
+ switch-matrix-16x1_18/Q OUT[6] OUT[7] OUT[0] OUT[12] OUT[5] OUT[15] CLK2 OUT[8]
+ VDD OUT[1] OUT[11] OUT[2] OUT[14] VSS OUT[3] switch-matrix-16x1
Xswitch-matrix-16x1_29 OUT[4] OUT[9] OUT[10] OUT[13] RSTN CLK1 IN[26] switch-matrix-16x1_29/Q
+ switch-matrix-16x1_29/D OUT[6] OUT[7] OUT[0] OUT[12] OUT[5] OUT[15] CLK2 OUT[8]
+ VDD OUT[1] OUT[11] OUT[2] OUT[14] VSS OUT[3] switch-matrix-16x1
Xswitch-matrix-16x1_18 OUT[4] OUT[9] OUT[10] OUT[13] RSTN CLK1 IN[24] switch-matrix-16x1_18/Q
+ switch-matrix-16x1_19/Q OUT[6] OUT[7] OUT[0] OUT[12] OUT[5] OUT[15] CLK2 OUT[8]
+ VDD OUT[1] OUT[11] OUT[2] OUT[14] VSS OUT[3] switch-matrix-16x1
Xswitch-matrix-16x1_19 OUT[4] OUT[9] OUT[10] OUT[13] RSTN CLK1 IN[25] switch-matrix-16x1_19/Q
+ switch-matrix-16x1_29/Q OUT[6] OUT[7] OUT[0] OUT[12] OUT[5] OUT[15] CLK2 OUT[8]
+ VDD OUT[1] OUT[11] OUT[2] OUT[14] VSS OUT[3] switch-matrix-16x1
.ends

.subckt nfet-vss G1 D1 S1 G2 D2 S2 VSS
XM13 S1 D1 G1 S1 G1 G1 S1 VSS D1 G1 nfet_06v0_52FGQA
Xnfet_06v0_52FGQA_0 S2 D2 G2 S2 G2 G2 S2 VSS D2 G2 nfet_06v0_52FGQA
.ends

.subckt top-level IBIAS RSTN CLK DATA VDD VSS IO[0] IO[1] IO[2] IO[3] IO[4] IO[5]
+ IO[6] IO[7] IO[8] IO[9] IO[10] IO[11] IO[12] IO[13] IO[14] IO[15]
Xpfet-com_0 pfet-com_0/G1 pfet-com_0/D1 pfet-com_0/G2 pfet-com_0/D2 pfet-com_0/G3
+ pfet-com_0/D3 pfet-com_0/G4 pfet-com_0/D4 VDD pfet-com
Xnfet-pin_0 nfet-pin_0/G1 nfet-pin_0/D1 nfet-pin_0/S1 nfet-pin_0/G2 nfet-pin_0/D2
+ nfet-pin_0/S2 nfet-pin_0/B nfet-pin
Xpfet-vdd_0 VDD pfet-vdd_0/G1 pfet-vdd_0/D1 pfet-vdd_0/S1 pfet-vdd_0/G2 pfet-vdd_0/D2
+ pfet-vdd_0/S2 pfet-vdd
Xn-ota_0 n-ota_0/OUT VDD IBIAS n-ota_0/VN n-ota_0/VP VSS n-ota
Xpfet-pin_0 pfet-pin_0/G1 pfet-pin_0/D1 pfet-pin_0/S1 pfet-pin_0/G2 pfet-pin_0/D2
+ pfet-pin_0/S2 pfet-pin_0/B pfet-pin
XNO_ClkGen_0 CLK clb_0/CLK2 clb_0/CLK1 VDD VSS NO_ClkGen
Xclb_0 clb_0/CLK1 clb_1/CLK1 clb_1/CLK2 clb_0/CLK_CLB clb_0/D clb_0/IN[0] clb_0/IN[1]
+ clb_0/OUT clb_1/D VDD VSS clb_0/CLK2 clb
Xnfet-com_0 nfet-com_0/G1 nfet-com_0/D1 nfet-com_0/G2 nfet-com_0/D2 nfet-com_0/G3
+ nfet-com_0/D3 nfet-com_0/G4 nfet-com_0/D4 VSS nfet-com
Xclb_2 clb_2/CLK1 clb_2/CLK1_BUFF clb_2/CLK2_BUFF clb_2/CLK_CLB clb_2/D clb_2/IN[0]
+ clb_2/IN[1] clb_2/OUT clb_2/Q VDD VSS clb_2/CLK2 clb
Xclb_1 clb_1/CLK1 clb_2/CLK1 clb_2/CLK2 clb_1/CLK_CLB clb_1/D clb_1/IN[0] clb_1/IN[1]
+ clb_1/OUT clb_2/D VDD VSS clb_1/CLK2 clb
Xswitch-matrix-16x70_0 RSTN clb_0/D IO[14] IO[13] IO[12] IO[11] IO[10] IO[9] IO[8]
+ IO[7] IO[6] IO[5] IO[4] IO[3] IO[2] IO[1] VDD nfet-com_0/D4 nfet-com_0/G4 nfet-com_0/D3
+ nfet-com_0/G3 nfet-com_0/D2 nfet-com_0/G2 nfet-com_0/D1 nfet-com_0/G1 pfet-com_0/D4
+ pfet-com_0/G4 pfet-com_0/D3 pfet-com_0/G3 pfet-com_0/D2 pfet-com_0/G2 pfet-com_0/D1
+ pfet-com_0/G1 nfet-pin_0/S2 nfet-pin_0/D2 nfet-pin_0/G2 nfet-pin_0/B nfet-pin_0/S1
+ nfet-pin_0/D1 nfet-pin_0/G1 pfet-pin_0/S2 pfet-pin_0/D2 pfet-pin_0/G2 pfet-pin_0/B
+ pfet-pin_0/S1 pfet-pin_0/D1 pfet-pin_0/G1 nfet-vss_0/S2 nfet-vss_0/D2 nfet-vss_0/G2
+ nfet-vss_0/S1 nfet-vss_0/D1 nfet-vss_0/G1 pfet-vdd_0/S2 pfet-vdd_0/D2 pfet-vdd_0/G2
+ pfet-vdd_0/S1 pfet-vdd_0/D1 pfet-vdd_0/G1 n-ota_0/OUT IBIAS n-ota_0/VP n-ota_0/VN
+ clb_2/CLK_CLB clb_2/OUT clb_2/IN[1] clb_2/IN[0] clb_1/CLK_CLB clb_1/OUT clb_1/IN[1]
+ clb_1/IN[0] clb_0/CLK_CLB clb_0/OUT clb_0/IN[1] clb_0/IN[0] VSS DATA clb_0/CLK2
+ clb_0/CLK1 IO[15] IO[0] VDD VSS switch-matrix-16x70
Xnfet-vss_0 nfet-vss_0/G1 nfet-vss_0/D1 nfet-vss_0/S1 nfet-vss_0/G2 nfet-vss_0/D2
+ nfet-vss_0/S2 VSS nfet-vss
.ends
