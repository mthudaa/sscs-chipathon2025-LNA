** sch_path: /foss/designs/sscs-chipathon2025-LNA/designs/libs/core_p-ota/pmos-ota/pmos-ota.sch
.subckt pmos-ota VBIAS VINN VINP OUT VDD VSS
*.PININFO VINN:I VINP:I OUT:O VDD:B VSS:B VBIAS:I
M1 net2 VINN net3 VDD pfet_03v3 L=10u W=18u nf=1 m=1
M2 net1 VINP net3 VDD pfet_03v3 L=10u W=18u nf=1 m=1
M3 net2 net1 VSS VSS nfet_03v3 L=10u W=6u nf=1 m=1
M4 net1 net1 VSS VSS nfet_03v3 L=10u W=6u nf=1 m=1
M5 net3 VBIAS VDD VDD pfet_03v3 L=10u W=18u nf=1 m=1
M7 OUT VBIAS VDD VDD pfet_03v3 L=2u W=6u nf=1 m=1
M8 OUT net2 VSS VSS nfet_03v3 L=2u W=4u nf=1 m=1
XC1 net4 net2 cap_mim_1f0fF c_width=5e-6 c_length=5e-6 m=1
XR1 OUT net4 VSS ppolyf_u_1k r_width=10e-6 r_length=10e-6 m=1
.ends
