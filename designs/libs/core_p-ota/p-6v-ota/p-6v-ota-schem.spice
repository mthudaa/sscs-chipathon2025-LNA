** sch_path: /foss/designs/sscs-chipathon2025-LNA/designs/libs/core_p-ota/p-6v-ota/p-6v-ota.sch
.subckt p-6v-ota OUT VSS VDD VN VP
*.PININFO VN:I VP:I OUT:O VDD:B VSS:B
M12 net5 VN net3 VDD pfet_06v0 L=2u W=8u nf=1 m=1
M13 net4 VP net3 VDD pfet_06v0 L=2u W=8u nf=1 m=1
M15 net5 net4 VSS VSS nfet_06v0 L=2u W=4u nf=1 m=1
M16 net4 net4 VSS VSS nfet_06v0 L=2u W=4u nf=1 m=1
M17 net3 net2 VDD VDD pfet_06v0 L=2u W=8u nf=1 m=1
M14 net1 net1 VDD VDD pfet_06v0 L=2u W=2u nf=1 m=1
M18 net2 net1 VDD VDD pfet_06v0 L=2u W=1u nf=1 m=1
M19 net2 net2 VSS VSS nfet_06v0 L=2u W=1u nf=1 m=1
M20 net1 net2 VSS VSS nfet_06v0 L=2u W=2u nf=1 m=1
M21 OUT net2 VDD VDD pfet_06v0 L=2u W=16u nf=1 m=1
M22 OUT net5 VSS VSS nfet_06v0 L=2u W=2u nf=1 m=1
XC2 net6 net5 cap_mim_1f0fF c_width=5e-6 c_length=5e-6 m=1
XR2 net6 OUT VSS ppolyf_u_1k r_width=5e-6 r_length=5e-6 m=1
.ends
