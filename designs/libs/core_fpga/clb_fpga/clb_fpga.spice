* NGSPICE file created from clb_module.ext - technology: gf180mcuD

* Black-box entry subcircuit for gf180mcu_fd_sc_mcu7t5v0__filltie abstract view
.subckt gf180mcu_fd_sc_mcu7t5v0__filltie VDD VSS
.ends

* Black-box entry subcircuit for gf180mcu_fd_sc_mcu7t5v0__fillcap_8 abstract view
.subckt gf180mcu_fd_sc_mcu7t5v0__fillcap_8 VDD VNW VPW VSS
.ends

* Black-box entry subcircuit for gf180mcu_fd_sc_mcu7t5v0__fillcap_4 abstract view
.subckt gf180mcu_fd_sc_mcu7t5v0__fillcap_4 VDD VNW VPW VSS
.ends

* Black-box entry subcircuit for gf180mcu_fd_sc_mcu7t5v0__endcap abstract view
.subckt gf180mcu_fd_sc_mcu7t5v0__endcap VDD VSS
.ends

* Black-box entry subcircuit for gf180mcu_fd_sc_mcu7t5v0__fill_2 abstract view
.subckt gf180mcu_fd_sc_mcu7t5v0__fill_2 VDD VNW VPW VSS
.ends

* Black-box entry subcircuit for gf180mcu_fd_sc_mcu7t5v0__fill_1 abstract view
.subckt gf180mcu_fd_sc_mcu7t5v0__fill_1 VDD VNW VPW VSS
.ends

* Black-box entry subcircuit for gf180mcu_fd_sc_mcu7t5v0__fillcap_16 abstract view
.subckt gf180mcu_fd_sc_mcu7t5v0__fillcap_16 VDD VNW VPW VSS
.ends

* Black-box entry subcircuit for gf180mcu_fd_sc_mcu7t5v0__dffrnq_1 abstract view
.subckt gf180mcu_fd_sc_mcu7t5v0__dffrnq_1 D RN CLK Q VDD VNW VPW VSS
.ends

* Black-box entry subcircuit for gf180mcu_fd_sc_mcu7t5v0__mux2_2 abstract view
.subckt gf180mcu_fd_sc_mcu7t5v0__mux2_2 I0 I1 S Z VDD VNW VPW VSS
.ends

* Black-box entry subcircuit for gf180mcu_fd_sc_mcu7t5v0__mux4_1 abstract view
.subckt gf180mcu_fd_sc_mcu7t5v0__mux4_1 I0 I1 I2 I3 S0 S1 Z VDD VNW VPW VSS
.ends

* Black-box entry subcircuit for gf180mcu_fd_sc_mcu7t5v0__clkinv_1 abstract view
.subckt gf180mcu_fd_sc_mcu7t5v0__clkinv_1 I ZN VDD VNW VPW VSS
.ends

* Black-box entry subcircuit for gf180mcu_fd_sc_mcu7t5v0__fillcap_32 abstract view
.subckt gf180mcu_fd_sc_mcu7t5v0__fillcap_32 VDD VNW VPW VSS
.ends

.subckt clb_fpga clk config_reg[0] config_reg[1] config_reg[2] config_reg[3] config_reg[4]
+ config_reg[5] in1 in2 out rst
XTAP_TAPCELL_ROW_2_13 _7_/VNW VSUBS gf180mcu_fd_sc_mcu7t5v0__filltie
XFILLER_3_36 _7_/VNW _7_/VNW VSUBS VSUBS gf180mcu_fd_sc_mcu7t5v0__fillcap_8
XFILLER_0_36 _5_/VNW _5_/VNW VSUBS VSUBS gf180mcu_fd_sc_mcu7t5v0__fillcap_8
XTAP_TAPCELL_ROW_5_15 _6_/VNW VSUBS gf180mcu_fd_sc_mcu7t5v0__filltie
XFILLER_1_2 _5_/VNW _5_/VNW VSUBS VSUBS gf180mcu_fd_sc_mcu7t5v0__fillcap_4
XFILLER_1_40 _5_/VNW _5_/VNW VSUBS VSUBS gf180mcu_fd_sc_mcu7t5v0__fillcap_4
XPHY_EDGE_ROW_1_Right_1 _5_/VNW VSUBS gf180mcu_fd_sc_mcu7t5v0__endcap
XFILLER_1_6 _5_/VNW _5_/VNW VSUBS VSUBS gf180mcu_fd_sc_mcu7t5v0__fill_2
XPHY_EDGE_ROW_0_Left_6 _5_/VNW VSUBS gf180mcu_fd_sc_mcu7t5v0__endcap
XPHY_EDGE_ROW_5_Right_5 _6_/VNW VSUBS gf180mcu_fd_sc_mcu7t5v0__endcap
XFILLER_1_44 _5_/VNW _5_/VNW VSUBS VSUBS gf180mcu_fd_sc_mcu7t5v0__fill_2
XFILLER_1_8 _5_/VNW _5_/VNW VSUBS VSUBS gf180mcu_fd_sc_mcu7t5v0__fill_1
XFILLER_4_45 _6_/VNW _6_/VNW VSUBS VSUBS gf180mcu_fd_sc_mcu7t5v0__fill_1
XFILLER_4_33 _6_/VNW _6_/VNW VSUBS VSUBS gf180mcu_fd_sc_mcu7t5v0__fill_2
XTAP_TAPCELL_ROW_0_12 _5_/VNW VSUBS gf180mcu_fd_sc_mcu7t5v0__filltie
XFILLER_1_24 _5_/VNW _5_/VNW VSUBS VSUBS gf180mcu_fd_sc_mcu7t5v0__fillcap_16
XFILLER_4_25 _6_/VNW _6_/VNW VSUBS VSUBS gf180mcu_fd_sc_mcu7t5v0__fillcap_8
XFILLER_4_37 _6_/VNW _6_/VNW VSUBS VSUBS gf180mcu_fd_sc_mcu7t5v0__fillcap_8
X_7_ _1_ _0_ clk ff_out _7_/VNW _7_/VNW VSUBS VSUBS gf180mcu_fd_sc_mcu7t5v0__dffrnq_1
XPHY_EDGE_ROW_0_Right_0 _5_/VNW VSUBS gf180mcu_fd_sc_mcu7t5v0__endcap
X_6_ _2_ ff_out config_reg[4] out _6_/VNW _6_/VNW VSUBS VSUBS gf180mcu_fd_sc_mcu7t5v0__mux2_2
XPHY_EDGE_ROW_1_Left_7 _5_/VNW VSUBS gf180mcu_fd_sc_mcu7t5v0__endcap
X_5_ ff_out _2_ config_reg[5] _1_ _5_/VNW _5_/VNW VSUBS VSUBS gf180mcu_fd_sc_mcu7t5v0__mux2_2
XFILLER_4_2 _6_/VNW _6_/VNW VSUBS VSUBS gf180mcu_fd_sc_mcu7t5v0__fillcap_8
X_4_ config_reg[0] config_reg[1] config_reg[2] config_reg[3] in1 in2 _2_ _7_/VNW _7_/VNW
+ VSUBS VSUBS gf180mcu_fd_sc_mcu7t5v0__mux4_1
X_3_ rst _0_ _6_/VNW _6_/VNW VSUBS VSUBS gf180mcu_fd_sc_mcu7t5v0__clkinv_1
XPHY_EDGE_ROW_4_Right_4 _6_/VNW VSUBS gf180mcu_fd_sc_mcu7t5v0__endcap
XFILLER_5_31 _6_/VNW _6_/VNW VSUBS VSUBS gf180mcu_fd_sc_mcu7t5v0__fill_2
XFILLER_5_44 _6_/VNW _6_/VNW VSUBS VSUBS gf180mcu_fd_sc_mcu7t5v0__fill_2
XFILLER_5_33 _6_/VNW _6_/VNW VSUBS VSUBS gf180mcu_fd_sc_mcu7t5v0__fill_1
XFILLER_5_10 _6_/VNW _6_/VNW VSUBS VSUBS gf180mcu_fd_sc_mcu7t5v0__fillcap_4
XPHY_EDGE_ROW_2_Left_8 _7_/VNW VSUBS gf180mcu_fd_sc_mcu7t5v0__endcap
XFILLER_2_45 _7_/VNW _7_/VNW VSUBS VSUBS gf180mcu_fd_sc_mcu7t5v0__fill_1
XFILLER_2_34 _7_/VNW _7_/VNW VSUBS VSUBS gf180mcu_fd_sc_mcu7t5v0__fill_1
XFILLER_0_2 _5_/VNW _5_/VNW VSUBS VSUBS gf180mcu_fd_sc_mcu7t5v0__fillcap_32
XPHY_EDGE_ROW_5_Left_11 _6_/VNW VSUBS gf180mcu_fd_sc_mcu7t5v0__endcap
XFILLER_5_36 _6_/VNW _6_/VNW VSUBS VSUBS gf180mcu_fd_sc_mcu7t5v0__fillcap_8
XFILLER_5_14 _6_/VNW _6_/VNW VSUBS VSUBS gf180mcu_fd_sc_mcu7t5v0__fill_1
XTAP_TAPCELL_ROW_4_14 _6_/VNW VSUBS gf180mcu_fd_sc_mcu7t5v0__filltie
XPHY_EDGE_ROW_3_Right_3 _7_/VNW VSUBS gf180mcu_fd_sc_mcu7t5v0__endcap
XFILLER_2_37 _7_/VNW _7_/VNW VSUBS VSUBS gf180mcu_fd_sc_mcu7t5v0__fillcap_8
XFILLER_5_27 _6_/VNW _6_/VNW VSUBS VSUBS gf180mcu_fd_sc_mcu7t5v0__fillcap_4
XPHY_EDGE_ROW_3_Left_9 _7_/VNW VSUBS gf180mcu_fd_sc_mcu7t5v0__endcap
XFILLER_5_19 _6_/VNW _6_/VNW VSUBS VSUBS gf180mcu_fd_sc_mcu7t5v0__fillcap_8
XPHY_EDGE_ROW_4_Left_10 _6_/VNW VSUBS gf180mcu_fd_sc_mcu7t5v0__endcap
XFILLER_5_2 _6_/VNW _6_/VNW VSUBS VSUBS gf180mcu_fd_sc_mcu7t5v0__fillcap_8
XPHY_EDGE_ROW_2_Right_2 _7_/VNW VSUBS gf180mcu_fd_sc_mcu7t5v0__endcap
XFILLER_0_44 _5_/VNW _5_/VNW VSUBS VSUBS gf180mcu_fd_sc_mcu7t5v0__fill_2
XFILLER_3_44 _7_/VNW _7_/VNW VSUBS VSUBS gf180mcu_fd_sc_mcu7t5v0__fill_2
.ends
