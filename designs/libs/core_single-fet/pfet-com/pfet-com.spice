** sch_path: /foss/designs/sscs-chipathon2025-LNA/designs/libs/core_single-fet/pfet-com/pfet-com.sch
.subckt pfet-com VDD D1 G1 D2 G2 D3 G3 D4 G4
*.PININFO VDD:B D1:B G1:B D2:B G2:B D3:B G3:B G4:B D4:B
M9 D1 G1 VDD VDD pfet_06v0 L=0.55u W=6.0u nf=1 m=2
M10 D2 G2 VDD VDD pfet_06v0 L=0.55u W=6.0u nf=1 m=2
M11 D3 G3 VDD VDD pfet_06v0 L=0.55u W=6.0u nf=1 m=4
M12 D4 G4 VDD VDD pfet_06v0 L=0.55u W=6.0u nf=1 m=4
.ends
