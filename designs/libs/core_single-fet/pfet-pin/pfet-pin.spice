** sch_path: /foss/designs/sscs-chipathon2025-LNA/designs/libs/core_single-fet/pfet-pin/pfet-pin.sch
.subckt pfet-pin B S1 G1 D1 S2 G2 D2
*.PININFO S1:B B:B G1:B D1:B S2:B G2:B D2:B
M5 D1 G1 S1 B pfet_06v0 L=0.55u W=6.0u nf=1 m=4
M6 D2 G2 S2 B pfet_06v0 L=0.55u W=6.0u nf=1 m=4
.ends
