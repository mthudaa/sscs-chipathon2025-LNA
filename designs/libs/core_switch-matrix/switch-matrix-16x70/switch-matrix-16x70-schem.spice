** sch_path: /foss/designs/sscs-chipathon2025-LNA/designs/libs/core_switch-matrix/switch-matrix-16x70/switch-matrix-16x70.sch
.subckt switch-matrix-16x70 D CLK1 CLK2 RSTN VDD VSS Q IN[75] IN[74] IN[73] IN[72] IN[71] IN[70] IN[69] IN[68] IN[67] IN[66]
+ IN[65] IN[64] IN[63] IN[62] IN[61] IN[60] IN[59] IN[58] IN[57] IN[56] IN[55] IN[54] IN[53] IN[52] IN[51] IN[50] IN[49] IN[48] IN[47]
+ IN[46] IN[45] IN[44] IN[43] IN[42] IN[41] IN[40] IN[39] IN[38] IN[37] IN[36] IN[35] IN[34] IN[33] IN[32] IN[31] IN[30] IN[29] IN[28]
+ IN[27] IN[26] IN[25] IN[24] IN[23] IN[22] IN[21] IN[20] IN[19] IN[18] IN[17] IN[16] IN[15] IN[14] IN[13] IN[12] IN[11] IN[10] IN[9]
+ IN[8] IN[7] IN[6] IN[5] IN[4] IN[3] IN[2] IN[1] IN[0] OUT[15] OUT[14] OUT[13] OUT[12] OUT[11] OUT[10] OUT[9] OUT[8] OUT[7] OUT[6]
+ OUT[5] OUT[4] OUT[3] OUT[2] OUT[1] OUT[0]
*.PININFO VDD:B VSS:B RSTN:I CLK1:I CLK2:I D:I IN[75:0]:B OUT[15:0]:B Q:O
x1 net1 VDD VSS IN[69] OUT[15] OUT[14] OUT[13] OUT[12] OUT[11] OUT[10] OUT[9] OUT[8] OUT[7] OUT[6] OUT[5] OUT[4] OUT[3] OUT[2]
+ OUT[1] OUT[0] D0 CLK1 CLK2 RSTN switch-matrix-16x1
x2 net2 VDD VSS IN[68] OUT[15] OUT[14] OUT[13] OUT[12] OUT[11] OUT[10] OUT[9] OUT[8] OUT[7] OUT[6] OUT[5] OUT[4] OUT[3] OUT[2]
+ OUT[1] OUT[0] net1 RSTN CLK2 RSTN switch-matrix-16x1
x3 net3 VDD VSS IN[67] OUT[15] OUT[14] OUT[13] OUT[12] OUT[11] OUT[10] OUT[9] OUT[8] OUT[7] OUT[6] OUT[5] OUT[4] OUT[3] OUT[2]
+ OUT[1] OUT[0] net2 RSTN CLK2 RSTN switch-matrix-16x1
x4 net4 VDD VSS IN[66] OUT[15] OUT[14] OUT[13] OUT[12] OUT[11] OUT[10] OUT[9] OUT[8] OUT[7] OUT[6] OUT[5] OUT[4] OUT[3] OUT[2]
+ OUT[1] OUT[0] net3 RSTN CLK2 RSTN switch-matrix-16x1
x5 net5 VDD VSS IN[65] OUT[15] OUT[14] OUT[13] OUT[12] OUT[11] OUT[10] OUT[9] OUT[8] OUT[7] OUT[6] OUT[5] OUT[4] OUT[3] OUT[2]
+ OUT[1] OUT[0] net4 RSTN CLK2 RSTN switch-matrix-16x1
x6 net6 VDD VSS IN[64] OUT[15] OUT[14] OUT[13] OUT[12] OUT[11] OUT[10] OUT[9] OUT[8] OUT[7] OUT[6] OUT[5] OUT[4] OUT[3] OUT[2]
+ OUT[1] OUT[0] net5 RSTN CLK2 RSTN switch-matrix-16x1
x7 net7 VDD VSS IN[63] OUT[15] OUT[14] OUT[13] OUT[12] OUT[11] OUT[10] OUT[9] OUT[8] OUT[7] OUT[6] OUT[5] OUT[4] OUT[3] OUT[2]
+ OUT[1] OUT[0] net6 RSTN CLK2 RSTN switch-matrix-16x1
x8 net8 VDD VSS IN[62] OUT[15] OUT[14] OUT[13] OUT[12] OUT[11] OUT[10] OUT[9] OUT[8] OUT[7] OUT[6] OUT[5] OUT[4] OUT[3] OUT[2]
+ OUT[1] OUT[0] net7 RSTN CLK2 RSTN switch-matrix-16x1
x9 net9 VDD VSS IN[61] OUT[15] OUT[14] OUT[13] OUT[12] OUT[11] OUT[10] OUT[9] OUT[8] OUT[7] OUT[6] OUT[5] OUT[4] OUT[3] OUT[2]
+ OUT[1] OUT[0] net8 RSTN CLK2 RSTN switch-matrix-16x1
x10 D1 VDD VSS IN[60] OUT[15] OUT[14] OUT[13] OUT[12] OUT[11] OUT[10] OUT[9] OUT[8] OUT[7] OUT[6] OUT[5] OUT[4] OUT[3] OUT[2]
+ OUT[1] OUT[0] net9 RSTN CLK2 RSTN switch-matrix-16x1
x11 net10 VDD VSS IN[59] OUT[15] OUT[14] OUT[13] OUT[12] OUT[11] OUT[10] OUT[9] OUT[8] OUT[7] OUT[6] OUT[5] OUT[4] OUT[3] OUT[2]
+ OUT[1] OUT[0] D1 CLK1 CLK2 RSTN switch-matrix-16x1
x12 net11 VDD VSS IN[58] OUT[15] OUT[14] OUT[13] OUT[12] OUT[11] OUT[10] OUT[9] OUT[8] OUT[7] OUT[6] OUT[5] OUT[4] OUT[3] OUT[2]
+ OUT[1] OUT[0] net10 RSTN CLK2 RSTN switch-matrix-16x1
x13 net12 VDD VSS IN[57] OUT[15] OUT[14] OUT[13] OUT[12] OUT[11] OUT[10] OUT[9] OUT[8] OUT[7] OUT[6] OUT[5] OUT[4] OUT[3] OUT[2]
+ OUT[1] OUT[0] net11 RSTN CLK2 RSTN switch-matrix-16x1
x14 net13 VDD VSS IN[56] OUT[15] OUT[14] OUT[13] OUT[12] OUT[11] OUT[10] OUT[9] OUT[8] OUT[7] OUT[6] OUT[5] OUT[4] OUT[3] OUT[2]
+ OUT[1] OUT[0] net12 RSTN CLK2 RSTN switch-matrix-16x1
x15 net14 VDD VSS IN[55] OUT[15] OUT[14] OUT[13] OUT[12] OUT[11] OUT[10] OUT[9] OUT[8] OUT[7] OUT[6] OUT[5] OUT[4] OUT[3] OUT[2]
+ OUT[1] OUT[0] net13 RSTN CLK2 RSTN switch-matrix-16x1
x16 net15 VDD VSS IN[54] OUT[15] OUT[14] OUT[13] OUT[12] OUT[11] OUT[10] OUT[9] OUT[8] OUT[7] OUT[6] OUT[5] OUT[4] OUT[3] OUT[2]
+ OUT[1] OUT[0] net14 RSTN CLK2 RSTN switch-matrix-16x1
x17 net16 VDD VSS IN[53] OUT[15] OUT[14] OUT[13] OUT[12] OUT[11] OUT[10] OUT[9] OUT[8] OUT[7] OUT[6] OUT[5] OUT[4] OUT[3] OUT[2]
+ OUT[1] OUT[0] net15 RSTN CLK2 RSTN switch-matrix-16x1
x18 net17 VDD VSS IN[52] OUT[15] OUT[14] OUT[13] OUT[12] OUT[11] OUT[10] OUT[9] OUT[8] OUT[7] OUT[6] OUT[5] OUT[4] OUT[3] OUT[2]
+ OUT[1] OUT[0] net16 RSTN CLK2 RSTN switch-matrix-16x1
x19 net18 VDD VSS IN[51] OUT[15] OUT[14] OUT[13] OUT[12] OUT[11] OUT[10] OUT[9] OUT[8] OUT[7] OUT[6] OUT[5] OUT[4] OUT[3] OUT[2]
+ OUT[1] OUT[0] net17 RSTN CLK2 RSTN switch-matrix-16x1
x20 D2 VDD VSS IN[50] OUT[15] OUT[14] OUT[13] OUT[12] OUT[11] OUT[10] OUT[9] OUT[8] OUT[7] OUT[6] OUT[5] OUT[4] OUT[3] OUT[2]
+ OUT[1] OUT[0] net18 RSTN CLK2 RSTN switch-matrix-16x1
x21 net19 VDD VSS IN[49] OUT[15] OUT[14] OUT[13] OUT[12] OUT[11] OUT[10] OUT[9] OUT[8] OUT[7] OUT[6] OUT[5] OUT[4] OUT[3] OUT[2]
+ OUT[1] OUT[0] D2 CLK1 CLK2 RSTN switch-matrix-16x1
x22 net20 VDD VSS IN[48] OUT[15] OUT[14] OUT[13] OUT[12] OUT[11] OUT[10] OUT[9] OUT[8] OUT[7] OUT[6] OUT[5] OUT[4] OUT[3] OUT[2]
+ OUT[1] OUT[0] net19 RSTN CLK2 RSTN switch-matrix-16x1
x23 net21 VDD VSS IN[47] OUT[15] OUT[14] OUT[13] OUT[12] OUT[11] OUT[10] OUT[9] OUT[8] OUT[7] OUT[6] OUT[5] OUT[4] OUT[3] OUT[2]
+ OUT[1] OUT[0] net20 RSTN CLK2 RSTN switch-matrix-16x1
x24 net22 VDD VSS IN[46] OUT[15] OUT[14] OUT[13] OUT[12] OUT[11] OUT[10] OUT[9] OUT[8] OUT[7] OUT[6] OUT[5] OUT[4] OUT[3] OUT[2]
+ OUT[1] OUT[0] net21 RSTN CLK2 RSTN switch-matrix-16x1
x25 net23 VDD VSS IN[45] OUT[15] OUT[14] OUT[13] OUT[12] OUT[11] OUT[10] OUT[9] OUT[8] OUT[7] OUT[6] OUT[5] OUT[4] OUT[3] OUT[2]
+ OUT[1] OUT[0] net22 RSTN CLK2 RSTN switch-matrix-16x1
x26 net24 VDD VSS IN[44] OUT[15] OUT[14] OUT[13] OUT[12] OUT[11] OUT[10] OUT[9] OUT[8] OUT[7] OUT[6] OUT[5] OUT[4] OUT[3] OUT[2]
+ OUT[1] OUT[0] net23 RSTN CLK2 RSTN switch-matrix-16x1
x27 net25 VDD VSS IN[43] OUT[15] OUT[14] OUT[13] OUT[12] OUT[11] OUT[10] OUT[9] OUT[8] OUT[7] OUT[6] OUT[5] OUT[4] OUT[3] OUT[2]
+ OUT[1] OUT[0] net24 RSTN CLK2 RSTN switch-matrix-16x1
x28 net26 VDD VSS IN[42] OUT[15] OUT[14] OUT[13] OUT[12] OUT[11] OUT[10] OUT[9] OUT[8] OUT[7] OUT[6] OUT[5] OUT[4] OUT[3] OUT[2]
+ OUT[1] OUT[0] net25 RSTN CLK2 RSTN switch-matrix-16x1
x29 net27 VDD VSS IN[41] OUT[15] OUT[14] OUT[13] OUT[12] OUT[11] OUT[10] OUT[9] OUT[8] OUT[7] OUT[6] OUT[5] OUT[4] OUT[3] OUT[2]
+ OUT[1] OUT[0] net26 RSTN CLK2 RSTN switch-matrix-16x1
x30 D3 VDD VSS IN[40] OUT[15] OUT[14] OUT[13] OUT[12] OUT[11] OUT[10] OUT[9] OUT[8] OUT[7] OUT[6] OUT[5] OUT[4] OUT[3] OUT[2]
+ OUT[1] OUT[0] net27 RSTN CLK2 RSTN switch-matrix-16x1
x31 net28 VDD VSS IN[39] OUT[15] OUT[14] OUT[13] OUT[12] OUT[11] OUT[10] OUT[9] OUT[8] OUT[7] OUT[6] OUT[5] OUT[4] OUT[3] OUT[2]
+ OUT[1] OUT[0] D3 CLK1 CLK2 RSTN switch-matrix-16x1
x32 net29 VDD VSS IN[38] OUT[15] OUT[14] OUT[13] OUT[12] OUT[11] OUT[10] OUT[9] OUT[8] OUT[7] OUT[6] OUT[5] OUT[4] OUT[3] OUT[2]
+ OUT[1] OUT[0] net28 RSTN CLK2 RSTN switch-matrix-16x1
x33 net30 VDD VSS IN[37] OUT[15] OUT[14] OUT[13] OUT[12] OUT[11] OUT[10] OUT[9] OUT[8] OUT[7] OUT[6] OUT[5] OUT[4] OUT[3] OUT[2]
+ OUT[1] OUT[0] net29 RSTN CLK2 RSTN switch-matrix-16x1
x34 net31 VDD VSS IN[36] OUT[15] OUT[14] OUT[13] OUT[12] OUT[11] OUT[10] OUT[9] OUT[8] OUT[7] OUT[6] OUT[5] OUT[4] OUT[3] OUT[2]
+ OUT[1] OUT[0] net30 RSTN CLK2 RSTN switch-matrix-16x1
x35 net32 VDD VSS IN[35] OUT[15] OUT[14] OUT[13] OUT[12] OUT[11] OUT[10] OUT[9] OUT[8] OUT[7] OUT[6] OUT[5] OUT[4] OUT[3] OUT[2]
+ OUT[1] OUT[0] net31 RSTN CLK2 RSTN switch-matrix-16x1
x36 net33 VDD VSS IN[34] OUT[15] OUT[14] OUT[13] OUT[12] OUT[11] OUT[10] OUT[9] OUT[8] OUT[7] OUT[6] OUT[5] OUT[4] OUT[3] OUT[2]
+ OUT[1] OUT[0] net32 RSTN CLK2 RSTN switch-matrix-16x1
x37 net34 VDD VSS IN[33] OUT[15] OUT[14] OUT[13] OUT[12] OUT[11] OUT[10] OUT[9] OUT[8] OUT[7] OUT[6] OUT[5] OUT[4] OUT[3] OUT[2]
+ OUT[1] OUT[0] net33 RSTN CLK2 RSTN switch-matrix-16x1
x38 net35 VDD VSS IN[32] OUT[15] OUT[14] OUT[13] OUT[12] OUT[11] OUT[10] OUT[9] OUT[8] OUT[7] OUT[6] OUT[5] OUT[4] OUT[3] OUT[2]
+ OUT[1] OUT[0] net34 RSTN CLK2 RSTN switch-matrix-16x1
x39 net36 VDD VSS IN[31] OUT[15] OUT[14] OUT[13] OUT[12] OUT[11] OUT[10] OUT[9] OUT[8] OUT[7] OUT[6] OUT[5] OUT[4] OUT[3] OUT[2]
+ OUT[1] OUT[0] net35 RSTN CLK2 RSTN switch-matrix-16x1
x40 D4 VDD VSS IN[30] OUT[15] OUT[14] OUT[13] OUT[12] OUT[11] OUT[10] OUT[9] OUT[8] OUT[7] OUT[6] OUT[5] OUT[4] OUT[3] OUT[2]
+ OUT[1] OUT[0] net36 RSTN CLK2 RSTN switch-matrix-16x1
x41 net37 VDD VSS IN[29] OUT[15] OUT[14] OUT[13] OUT[12] OUT[11] OUT[10] OUT[9] OUT[8] OUT[7] OUT[6] OUT[5] OUT[4] OUT[3] OUT[2]
+ OUT[1] OUT[0] D4 CLK1 CLK2 RSTN switch-matrix-16x1
x42 net38 VDD VSS IN[28] OUT[15] OUT[14] OUT[13] OUT[12] OUT[11] OUT[10] OUT[9] OUT[8] OUT[7] OUT[6] OUT[5] OUT[4] OUT[3] OUT[2]
+ OUT[1] OUT[0] net37 RSTN CLK2 RSTN switch-matrix-16x1
x43 net39 VDD VSS IN[27] OUT[15] OUT[14] OUT[13] OUT[12] OUT[11] OUT[10] OUT[9] OUT[8] OUT[7] OUT[6] OUT[5] OUT[4] OUT[3] OUT[2]
+ OUT[1] OUT[0] net38 RSTN CLK2 RSTN switch-matrix-16x1
x44 net40 VDD VSS IN[26] OUT[15] OUT[14] OUT[13] OUT[12] OUT[11] OUT[10] OUT[9] OUT[8] OUT[7] OUT[6] OUT[5] OUT[4] OUT[3] OUT[2]
+ OUT[1] OUT[0] net39 RSTN CLK2 RSTN switch-matrix-16x1
x45 net41 VDD VSS IN[25] OUT[15] OUT[14] OUT[13] OUT[12] OUT[11] OUT[10] OUT[9] OUT[8] OUT[7] OUT[6] OUT[5] OUT[4] OUT[3] OUT[2]
+ OUT[1] OUT[0] net40 RSTN CLK2 RSTN switch-matrix-16x1
x46 net42 VDD VSS IN[24] OUT[15] OUT[14] OUT[13] OUT[12] OUT[11] OUT[10] OUT[9] OUT[8] OUT[7] OUT[6] OUT[5] OUT[4] OUT[3] OUT[2]
+ OUT[1] OUT[0] net41 RSTN CLK2 RSTN switch-matrix-16x1
x47 net43 VDD VSS IN[23] OUT[15] OUT[14] OUT[13] OUT[12] OUT[11] OUT[10] OUT[9] OUT[8] OUT[7] OUT[6] OUT[5] OUT[4] OUT[3] OUT[2]
+ OUT[1] OUT[0] net42 RSTN CLK2 RSTN switch-matrix-16x1
x48 net44 VDD VSS IN[22] OUT[15] OUT[14] OUT[13] OUT[12] OUT[11] OUT[10] OUT[9] OUT[8] OUT[7] OUT[6] OUT[5] OUT[4] OUT[3] OUT[2]
+ OUT[1] OUT[0] net43 RSTN CLK2 RSTN switch-matrix-16x1
x49 net45 VDD VSS IN[21] OUT[15] OUT[14] OUT[13] OUT[12] OUT[11] OUT[10] OUT[9] OUT[8] OUT[7] OUT[6] OUT[5] OUT[4] OUT[3] OUT[2]
+ OUT[1] OUT[0] net44 RSTN CLK2 RSTN switch-matrix-16x1
x50 D5 VDD VSS IN[20] OUT[15] OUT[14] OUT[13] OUT[12] OUT[11] OUT[10] OUT[9] OUT[8] OUT[7] OUT[6] OUT[5] OUT[4] OUT[3] OUT[2]
+ OUT[1] OUT[0] net45 RSTN CLK2 RSTN switch-matrix-16x1
x51 net46 VDD VSS IN[19] OUT[15] OUT[14] OUT[13] OUT[12] OUT[11] OUT[10] OUT[9] OUT[8] OUT[7] OUT[6] OUT[5] OUT[4] OUT[3] OUT[2]
+ OUT[1] OUT[0] D5 CLK1 CLK2 RSTN switch-matrix-16x1
x52 net47 VDD VSS IN[18] OUT[15] OUT[14] OUT[13] OUT[12] OUT[11] OUT[10] OUT[9] OUT[8] OUT[7] OUT[6] OUT[5] OUT[4] OUT[3] OUT[2]
+ OUT[1] OUT[0] net46 RSTN CLK2 RSTN switch-matrix-16x1
x53 net48 VDD VSS IN[17] OUT[15] OUT[14] OUT[13] OUT[12] OUT[11] OUT[10] OUT[9] OUT[8] OUT[7] OUT[6] OUT[5] OUT[4] OUT[3] OUT[2]
+ OUT[1] OUT[0] net47 RSTN CLK2 RSTN switch-matrix-16x1
x54 net49 VDD VSS IN[16] OUT[15] OUT[14] OUT[13] OUT[12] OUT[11] OUT[10] OUT[9] OUT[8] OUT[7] OUT[6] OUT[5] OUT[4] OUT[3] OUT[2]
+ OUT[1] OUT[0] net48 RSTN CLK2 RSTN switch-matrix-16x1
x55 net50 VDD VSS IN[15] OUT[15] OUT[14] OUT[13] OUT[12] OUT[11] OUT[10] OUT[9] OUT[8] OUT[7] OUT[6] OUT[5] OUT[4] OUT[3] OUT[2]
+ OUT[1] OUT[0] net49 RSTN CLK2 RSTN switch-matrix-16x1
x56 net51 VDD VSS IN[14] OUT[15] OUT[14] OUT[13] OUT[12] OUT[11] OUT[10] OUT[9] OUT[8] OUT[7] OUT[6] OUT[5] OUT[4] OUT[3] OUT[2]
+ OUT[1] OUT[0] net50 RSTN CLK2 RSTN switch-matrix-16x1
x57 net52 VDD VSS IN[13] OUT[15] OUT[14] OUT[13] OUT[12] OUT[11] OUT[10] OUT[9] OUT[8] OUT[7] OUT[6] OUT[5] OUT[4] OUT[3] OUT[2]
+ OUT[1] OUT[0] net51 RSTN CLK2 RSTN switch-matrix-16x1
x58 net53 VDD VSS IN[12] OUT[15] OUT[14] OUT[13] OUT[12] OUT[11] OUT[10] OUT[9] OUT[8] OUT[7] OUT[6] OUT[5] OUT[4] OUT[3] OUT[2]
+ OUT[1] OUT[0] net52 RSTN CLK2 RSTN switch-matrix-16x1
x59 net54 VDD VSS IN[11] OUT[15] OUT[14] OUT[13] OUT[12] OUT[11] OUT[10] OUT[9] OUT[8] OUT[7] OUT[6] OUT[5] OUT[4] OUT[3] OUT[2]
+ OUT[1] OUT[0] net53 RSTN CLK2 RSTN switch-matrix-16x1
x60 D6 VDD VSS IN[10] OUT[15] OUT[14] OUT[13] OUT[12] OUT[11] OUT[10] OUT[9] OUT[8] OUT[7] OUT[6] OUT[5] OUT[4] OUT[3] OUT[2]
+ OUT[1] OUT[0] net54 RSTN CLK2 RSTN switch-matrix-16x1
x61 net55 VDD VSS IN[9] OUT[15] OUT[14] OUT[13] OUT[12] OUT[11] OUT[10] OUT[9] OUT[8] OUT[7] OUT[6] OUT[5] OUT[4] OUT[3] OUT[2]
+ OUT[1] OUT[0] D6 CLK1 CLK2 RSTN switch-matrix-16x1
x62 net56 VDD VSS IN[8] OUT[15] OUT[14] OUT[13] OUT[12] OUT[11] OUT[10] OUT[9] OUT[8] OUT[7] OUT[6] OUT[5] OUT[4] OUT[3] OUT[2]
+ OUT[1] OUT[0] net55 RSTN CLK2 RSTN switch-matrix-16x1
x63 net57 VDD VSS IN[7] OUT[15] OUT[14] OUT[13] OUT[12] OUT[11] OUT[10] OUT[9] OUT[8] OUT[7] OUT[6] OUT[5] OUT[4] OUT[3] OUT[2]
+ OUT[1] OUT[0] net56 RSTN CLK2 RSTN switch-matrix-16x1
x64 net58 VDD VSS IN[6] OUT[15] OUT[14] OUT[13] OUT[12] OUT[11] OUT[10] OUT[9] OUT[8] OUT[7] OUT[6] OUT[5] OUT[4] OUT[3] OUT[2]
+ OUT[1] OUT[0] net57 RSTN CLK2 RSTN switch-matrix-16x1
x65 net59 VDD VSS IN[5] OUT[15] OUT[14] OUT[13] OUT[12] OUT[11] OUT[10] OUT[9] OUT[8] OUT[7] OUT[6] OUT[5] OUT[4] OUT[3] OUT[2]
+ OUT[1] OUT[0] net58 RSTN CLK2 RSTN switch-matrix-16x1
x66 net60 VDD VSS IN[4] OUT[15] OUT[14] OUT[13] OUT[12] OUT[11] OUT[10] OUT[9] OUT[8] OUT[7] OUT[6] OUT[5] OUT[4] OUT[3] OUT[2]
+ OUT[1] OUT[0] net59 RSTN CLK2 RSTN switch-matrix-16x1
x67 net61 VDD VSS IN[3] OUT[15] OUT[14] OUT[13] OUT[12] OUT[11] OUT[10] OUT[9] OUT[8] OUT[7] OUT[6] OUT[5] OUT[4] OUT[3] OUT[2]
+ OUT[1] OUT[0] net60 RSTN CLK2 RSTN switch-matrix-16x1
x68 net62 VDD VSS IN[2] OUT[15] OUT[14] OUT[13] OUT[12] OUT[11] OUT[10] OUT[9] OUT[8] OUT[7] OUT[6] OUT[5] OUT[4] OUT[3] OUT[2]
+ OUT[1] OUT[0] net61 RSTN CLK2 RSTN switch-matrix-16x1
x69 net63 VDD VSS IN[1] OUT[15] OUT[14] OUT[13] OUT[12] OUT[11] OUT[10] OUT[9] OUT[8] OUT[7] OUT[6] OUT[5] OUT[4] OUT[3] OUT[2]
+ OUT[1] OUT[0] net62 RSTN CLK2 RSTN switch-matrix-16x1
x70 Q VDD VSS IN[0] OUT[15] OUT[14] OUT[13] OUT[12] OUT[11] OUT[10] OUT[9] OUT[8] OUT[7] OUT[6] OUT[5] OUT[4] OUT[3] OUT[2] OUT[1]
+ OUT[0] net63 RSTN CLK2 RSTN switch-matrix-16x1
x75 net64 VDD VSS IN[75] OUT[15] OUT[14] OUT[13] OUT[12] OUT[11] OUT[10] OUT[9] OUT[8] OUT[7] OUT[6] OUT[5] OUT[4] OUT[3] OUT[2]
+ OUT[1] OUT[0] D CLK1 CLK2 RSTN switch-matrix-16x1
x76 net65 VDD VSS IN[74] OUT[15] OUT[14] OUT[13] OUT[12] OUT[11] OUT[10] OUT[9] OUT[8] OUT[7] OUT[6] OUT[5] OUT[4] OUT[3] OUT[2]
+ OUT[1] OUT[0] net64 RSTN CLK2 RSTN switch-matrix-16x1
x77 net66 VDD VSS IN[73] OUT[15] OUT[14] OUT[13] OUT[12] OUT[11] OUT[10] OUT[9] OUT[8] OUT[7] OUT[6] OUT[5] OUT[4] OUT[3] OUT[2]
+ OUT[1] OUT[0] net65 RSTN CLK2 RSTN switch-matrix-16x1
x78 net67 VDD VSS IN[72] OUT[15] OUT[14] OUT[13] OUT[12] OUT[11] OUT[10] OUT[9] OUT[8] OUT[7] OUT[6] OUT[5] OUT[4] OUT[3] OUT[2]
+ OUT[1] OUT[0] net66 RSTN CLK2 RSTN switch-matrix-16x1
x79 net68 VDD VSS IN[71] OUT[15] OUT[14] OUT[13] OUT[12] OUT[11] OUT[10] OUT[9] OUT[8] OUT[7] OUT[6] OUT[5] OUT[4] OUT[3] OUT[2]
+ OUT[1] OUT[0] net67 RSTN CLK2 RSTN switch-matrix-16x1
x80 D0 VDD VSS IN[70] OUT[15] OUT[14] OUT[13] OUT[12] OUT[11] OUT[10] OUT[9] OUT[8] OUT[7] OUT[6] OUT[5] OUT[4] OUT[3] OUT[2]
+ OUT[1] OUT[0] net68 RSTN CLK2 RSTN switch-matrix-16x1
.ends

* expanding   symbol:  core_switch-matrix/switch-matrix-16x1/switch-matrix-16x1.sym # of pins=9
** sym_path: /foss/designs/sscs-chipathon2025-LNA/designs/libs/core_switch-matrix/switch-matrix-16x1/switch-matrix-16x1.sym
** sch_path: /foss/designs/sscs-chipathon2025-LNA/designs/libs/core_switch-matrix/switch-matrix-16x1/switch-matrix-16x1.sch
.subckt switch-matrix-16x1 Q VDD VSS IN OUT[15] OUT[14] OUT[13] OUT[12] OUT[11] OUT[10] OUT[9] OUT[8] OUT[7] OUT[6] OUT[5] OUT[4]
+ OUT[3] OUT[2] OUT[1] OUT[0] D CLK1 CLK2 RSTN
*.PININFO VDD:B VSS:B IN:B OUT[15:0]:B D:I RSTN:I Q:O CLK1:I CLK2:I
x1 net10 VDD VSS D CLK1 CLK2 RSTN IN OUT[15] switch-cell
x2 net11 VDD VSS net10 CLK1 CLK2 RSTN IN OUT[14] switch-cell
x3 net12 VDD VSS net11 CLK1 CLK2 RSTN IN OUT[13] switch-cell
x4 net13 VDD VSS net12 CLK1 CLK2 RSTN IN OUT[12] switch-cell
x5 net7 VDD VSS net13 CLK1 CLK2 RSTN IN OUT[11] switch-cell
x6 net8 VDD VSS net7 CLK1 CLK2 RSTN IN OUT[10] switch-cell
x7 net9 VDD VSS net8 CLK1 CLK2 RSTN IN OUT[9] switch-cell
x8 net14 VDD VSS net9 CLK1 CLK2 RSTN IN OUT[8] switch-cell
x9 net4 VDD VSS net14 CLK1 CLK2 RSTN IN OUT[7] switch-cell
x10 net5 VDD VSS net4 CLK1 CLK2 RSTN IN OUT[6] switch-cell
x11 net6 VDD VSS net5 CLK1 CLK2 RSTN IN OUT[5] switch-cell
x12 net15 VDD VSS net6 CLK1 CLK2 RSTN IN OUT[4] switch-cell
x13 net1 VDD VSS net15 CLK1 CLK2 RSTN IN OUT[3] switch-cell
x14 net2 VDD VSS net1 CLK1 CLK2 RSTN IN OUT[2] switch-cell
x15 net3 VDD VSS net2 CLK1 CLK2 RSTN IN OUT[1] switch-cell
x16 Q VDD VSS net3 CLK1 CLK2 RSTN IN OUT[0] switch-cell
.ends

* expanding   symbol:  core_switch-matrix/switch-cell/switch-cell.sym # of pins=9
** sym_path: /foss/designs/sscs-chipathon2025-LNA/designs/libs/core_switch-matrix/switch-cell/switch-cell.sym
** sch_path: /foss/designs/sscs-chipathon2025-LNA/designs/libs/core_switch-matrix/switch-cell/switch-cell.sch
.subckt switch-cell Q VDD VSS D CLK1 CLK2 RSTN IN OUT
*.PININFO VDD:B VSS:B CLK1:I D:I IN:B OUT:B RSTN:I Q:O CLK2:I
x4 VDD VSS SWN SWP IN OUT trans-gate
x1 D CLK1 net1 VDD VDD VSS VSS gf180mcu_fd_sc_mcu9t5v0__latq_1
x5 net1 CLK2 Q VDD VDD VSS VSS gf180mcu_fd_sc_mcu9t5v0__latq_1
x2 Q RSTN SWN VDD VDD VSS VSS gf180mcu_fd_sc_mcu9t5v0__and2_1
x3 SWN SWP VDD VDD VSS VSS gf180mcu_fd_sc_mcu9t5v0__inv_1
**** begin user architecture code

.include /foss/pdks/gf180mcuD/libs.ref/gf180mcu_fd_sc_mcu9t5v0/spice/gf180mcu_fd_sc_mcu9t5v0.spice
.include /foss/designs/Chipathon2025_pads/xschem/gf180mcu_fd_io__asig_5p0_extracted.spice
.include /foss/designs/Chipathon2025_pads/xschem/gf180mcu_fd_io.spice
.include /foss/pdks/gf180mcuD/libs.tech/ngspice/design.ngspice
.lib /foss/pdks/gf180mcuD/libs.tech/ngspice/sm141064.ngspice typical
.lib /foss/pdks/gf180mcuD/libs.tech/ngspice/sm141064.ngspice cap_mim
.lib /foss/pdks/gf180mcuD/libs.tech/ngspice/sm141064.ngspice res_typical
.lib /foss/pdks/gf180mcuD/libs.tech/ngspice/sm141064.ngspice moscap_typical
.lib /foss/pdks/gf180mcuD/libs.tech/ngspice/sm141064.ngspice mimcap_typical
.lib /foss/pdks/gf180mcuD/libs.tech/ngspice/sm141064.ngspice diode_typical

**** end user architecture code
.ends

* expanding   symbol:  core_switch-matrix/trans-gate/trans-gate.sym # of pins=6
** sym_path: /foss/designs/sscs-chipathon2025-LNA/designs/libs/core_switch-matrix/trans-gate/trans-gate.sym
** sch_path: /foss/designs/sscs-chipathon2025-LNA/designs/libs/core_switch-matrix/trans-gate/trans-gate.sch
.subckt trans-gate VDD VSS SWN SWP IN OUT
*.PININFO VDD:B VSS:B IN:B OUT:B SWN:I SWP:I
M1 IN SWN OUT VSS nfet_06v0 L=0.70u W=8u nf=1 m=3
M2 IN SWP OUT VDD pfet_06v0 L=0.55u W=8u nf=1 m=9
.ends
