* Extracted by KLayout with GF180MCU LVS runset on : 25/09/2025 04:14

.SUBCKT test
.ENDS test
